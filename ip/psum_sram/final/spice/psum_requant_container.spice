* NGSPICE file created from psum_requant_container.ext - technology: ihp-sg13cmos5l

* Black-box entry subcircuit for sg13cmos5l_decap_8 abstract view
.subckt sg13cmos5l_decap_8 VDD VSS
.ends

* Black-box entry subcircuit for sg13cmos5l_fill_2 abstract view
.subckt sg13cmos5l_fill_2 VDD VSS
.ends

* Black-box entry subcircuit for sg13cmos5l_fill_1 abstract view
.subckt sg13cmos5l_fill_1 VDD VSS
.ends

* Black-box entry subcircuit for sg13cmos5l_o21ai_1 abstract view
.subckt sg13cmos5l_o21ai_1 Y A1 A2 B1 VDD VSS
.ends

* Black-box entry subcircuit for sg13cmos5l_nor2_1 abstract view
.subckt sg13cmos5l_nor2_1 Y A B VDD VSS
.ends

* Black-box entry subcircuit for sg13cmos5l_nor2b_1 abstract view
.subckt sg13cmos5l_nor2b_1 Y A B_N VDD VSS
.ends

* Black-box entry subcircuit for sg13cmos5l_a21o_1 abstract view
.subckt sg13cmos5l_a21o_1 X A1 A2 B1 VDD VSS
.ends

* Black-box entry subcircuit for sg13cmos5l_xor2_1 abstract view
.subckt sg13cmos5l_xor2_1 X A B VDD VSS
.ends

* Black-box entry subcircuit for sg13cmos5l_xnor2_1 abstract view
.subckt sg13cmos5l_xnor2_1 Y A B VDD VSS
.ends

* Black-box entry subcircuit for sg13cmos5l_nand2_1 abstract view
.subckt sg13cmos5l_nand2_1 Y A B VDD VSS
.ends

* Black-box entry subcircuit for sg13cmos5l_tielo abstract view
.subckt sg13cmos5l_tielo L_LO VDD VSS
.ends

* Black-box entry subcircuit for sg13cmos5l_decap_4 abstract view
.subckt sg13cmos5l_decap_4 VDD VSS
.ends

* Black-box entry subcircuit for sg13cmos5l_nor2b_2 abstract view
.subckt sg13cmos5l_nor2b_2 Y A B_N VDD VSS
.ends

* Black-box entry subcircuit for sg13cmos5l_buf_1 abstract view
.subckt sg13cmos5l_buf_1 X A VDD VSS
.ends

* Black-box entry subcircuit for sg13cmos5l_and2_1 abstract view
.subckt sg13cmos5l_and2_1 X A B VDD VSS
.ends

* Black-box entry subcircuit for sg13cmos5l_a21oi_1 abstract view
.subckt sg13cmos5l_a21oi_1 Y A1 A2 B1 VDD VSS
.ends

* Black-box entry subcircuit for sg13cmos5l_mux2_1 abstract view
.subckt sg13cmos5l_mux2_1 X A0 A1 S VDD VSS
.ends

* Black-box entry subcircuit for sg13cmos5l_dfrbpq_1 abstract view
.subckt sg13cmos5l_dfrbpq_1 Q CLK D RESET_B VDD VSS
.ends

* Black-box entry subcircuit for sg13cmos5l_inv_1 abstract view
.subckt sg13cmos5l_inv_1 Y A VDD VSS
.ends

* Black-box entry subcircuit for sg13cmos5l_nand2_2 abstract view
.subckt sg13cmos5l_nand2_2 Y A B VDD VSS
.ends

* Black-box entry subcircuit for sg13cmos5l_a22oi_1 abstract view
.subckt sg13cmos5l_a22oi_1 Y A1 A2 B1 B2 VDD VSS
.ends

* Black-box entry subcircuit for sg13cmos5l_nor3_1 abstract view
.subckt sg13cmos5l_nor3_1 Y A B C VDD VSS
.ends

* Black-box entry subcircuit for sg13cmos5l_buf_2 abstract view
.subckt sg13cmos5l_buf_2 X A VDD VSS
.ends

* Black-box entry subcircuit for sg13cmos5l_nand2b_1 abstract view
.subckt sg13cmos5l_nand2b_1 Y A_N B VDD VSS
.ends

* Black-box entry subcircuit for sg13cmos5l_nand3_1 abstract view
.subckt sg13cmos5l_nand3_1 Y A B C VDD VSS
.ends

* Black-box entry subcircuit for sg13cmos5l_antennanp abstract view
.subckt sg13cmos5l_antennanp A VDD VSS
.ends

* Black-box entry subcircuit for sg13cmos5l_tiehi abstract view
.subckt sg13cmos5l_tiehi L_HI VDD VSS
.ends

* Black-box entry subcircuit for sg13cmos5l_nor2_2 abstract view
.subckt sg13cmos5l_nor2_2 Y A B VDD VSS
.ends

* Black-box entry subcircuit for sg13cmos5l_nor3_2 abstract view
.subckt sg13cmos5l_nor3_2 Y A B C VDD VSS
.ends

* Black-box entry subcircuit for sg13cmos5l_buf_4 abstract view
.subckt sg13cmos5l_buf_4 X A VDD VSS
.ends

* Black-box entry subcircuit for sg13cmos5l_buf_8 abstract view
.subckt sg13cmos5l_buf_8 X A VDD VSS
.ends

* Black-box entry subcircuit for sg13cmos5l_a21oi_2 abstract view
.subckt sg13cmos5l_a21oi_2 Y A1 A2 B1 VDD VSS
.ends

* Black-box entry subcircuit for sg13cmos5l_and3_1 abstract view
.subckt sg13cmos5l_and3_1 X A B C VDD VSS
.ends

* Black-box entry subcircuit for sg13cmos5l_nor4_1 abstract view
.subckt sg13cmos5l_nor4_1 Y A B C D VDD VSS
.ends

* Black-box entry subcircuit for sg13cmos5l_inv_4 abstract view
.subckt sg13cmos5l_inv_4 Y A VDD VSS
.ends

* Black-box entry subcircuit for sg13cmos5l_nand4_1 abstract view
.subckt sg13cmos5l_nand4_1 Y A B C D VDD VSS
.ends

* Black-box entry subcircuit for sg13cmos5l_buf_16 abstract view
.subckt sg13cmos5l_buf_16 X A VDD VSS
.ends

* Black-box entry subcircuit for sg13cmos5l_dlygate4sd3_1 abstract view
.subckt sg13cmos5l_dlygate4sd3_1 X A VDD VSS
.ends

* Black-box entry subcircuit for sg13cmos5l_inv_2 abstract view
.subckt sg13cmos5l_inv_2 Y A VDD VSS
.ends

* Black-box entry subcircuit for sg13cmos5l_nand2b_2 abstract view
.subckt sg13cmos5l_nand2b_2 Y A_N B VDD VSS
.ends

* Black-box entry subcircuit for sg13cmos5l_a221oi_1 abstract view
.subckt sg13cmos5l_a221oi_1 Y A1 A2 B1 B2 C1 VDD VSS
.ends

* Black-box entry subcircuit for sg13cmos5l_or2_1 abstract view
.subckt sg13cmos5l_or2_1 X A B VDD VSS
.ends

* Black-box entry subcircuit for sg13cmos5l_dfrbpq_2 abstract view
.subckt sg13cmos5l_dfrbpq_2 Q CLK D RESET_B VDD VSS
.ends

* Black-box entry subcircuit for sg13cmos5l_nor4_2 abstract view
.subckt sg13cmos5l_nor4_2 Y A B C D VDD VSS
.ends

* Black-box entry subcircuit for sg13cmos5l_and4_1 abstract view
.subckt sg13cmos5l_and4_1 X A B C D VDD VSS
.ends

* Black-box entry subcircuit for sg13cmos5l_nand3b_1 abstract view
.subckt sg13cmos5l_nand3b_1 Y A_N B C VDD VSS
.ends

* Black-box entry subcircuit for RM_IHPSG13_1P_256x32_c2_bm_bist abstract view
.subckt RM_IHPSG13_1P_256x32_c2_bm_bist A_DIN[16] A_DIN[15] A_BIST_DIN[16] A_BIST_DIN[15]
+ A_BM[16] A_BM[15] A_BIST_BM[16] A_BIST_BM[15] A_DOUT[16] A_DOUT[15] VSS VDD VDDARRAY
+ A_DIN[17] A_DIN[14] A_BIST_DIN[17] A_BIST_DIN[14] A_BM[17] A_BM[14] A_BIST_BM[17]
+ A_BIST_BM[14] A_DOUT[17] A_DOUT[14] A_DIN[18] A_DIN[13] A_BIST_DIN[18] A_BIST_DIN[13]
+ A_BM[18] A_BM[13] A_BIST_BM[18] A_BIST_BM[13] A_DOUT[18] A_DOUT[13] A_DIN[19] A_DIN[12]
+ A_BIST_DIN[19] A_BIST_DIN[12] A_BM[19] A_BM[12] A_BIST_BM[19] A_BIST_BM[12] A_DOUT[19]
+ A_DOUT[12] A_DIN[20] A_DIN[11] A_BIST_DIN[20] A_BIST_DIN[11] A_BM[20] A_BM[11] A_BIST_BM[20]
+ A_BIST_BM[11] A_DOUT[20] A_DOUT[11] A_DIN[21] A_DIN[10] A_BIST_DIN[21] A_BIST_DIN[10]
+ A_BM[21] A_BM[10] A_BIST_BM[21] A_BIST_BM[10] A_DOUT[21] A_DOUT[10] A_DIN[22] A_DIN[9]
+ A_BIST_DIN[22] A_BIST_DIN[9] A_BM[22] A_BM[9] A_BIST_BM[22] A_BIST_BM[9] A_DOUT[22]
+ A_DOUT[9] A_DIN[23] A_DIN[8] A_BIST_DIN[23] A_BIST_DIN[8] A_BM[23] A_BM[8] A_BIST_BM[23]
+ A_BIST_BM[8] A_DOUT[23] A_DOUT[8] A_DIN[24] A_DIN[7] A_BIST_DIN[24] A_BIST_DIN[7]
+ A_BM[24] A_BM[7] A_BIST_BM[24] A_BIST_BM[7] A_DOUT[24] A_DOUT[7] A_DIN[25] A_DIN[6]
+ A_BIST_DIN[25] A_BIST_DIN[6] A_BM[25] A_BM[6] A_BIST_BM[25] A_BIST_BM[6] A_DOUT[25]
+ A_DOUT[6] A_DIN[26] A_DIN[5] A_BIST_DIN[26] A_BIST_DIN[5] A_BM[26] A_BM[5] A_BIST_BM[26]
+ A_BIST_BM[5] A_DOUT[26] A_DOUT[5] A_DIN[27] A_DIN[4] A_BIST_DIN[27] A_BIST_DIN[4]
+ A_BM[27] A_BM[4] A_BIST_BM[27] A_BIST_BM[4] A_DOUT[27] A_DOUT[4] A_DIN[28] A_DIN[3]
+ A_BIST_DIN[28] A_BIST_DIN[3] A_BM[28] A_BM[3] A_BIST_BM[28] A_BIST_BM[3] A_DOUT[28]
+ A_DOUT[3] A_DIN[29] A_DIN[2] A_BIST_DIN[29] A_BIST_DIN[2] A_BM[29] A_BM[2] A_BIST_BM[29]
+ A_BIST_BM[2] A_DOUT[29] A_DOUT[2] A_DIN[30] A_DIN[1] A_BIST_DIN[30] A_BIST_DIN[1]
+ A_BM[30] A_BM[1] A_BIST_BM[30] A_BIST_BM[1] A_DOUT[30] A_DOUT[1] A_DIN[31] A_DIN[0]
+ A_BIST_DIN[31] A_BIST_DIN[0] A_BM[31] A_BM[0] A_BIST_BM[31] A_BIST_BM[0] A_DOUT[31]
+ A_DOUT[0] A_ADDR[0] A_BIST_ADDR[0] A_ADDR[1] A_BIST_ADDR[1] A_ADDR[2] A_BIST_ADDR[2]
+ A_ADDR[3] A_BIST_ADDR[3] A_ADDR[4] A_BIST_ADDR[4] A_ADDR[5] A_BIST_ADDR[5] A_ADDR[6]
+ A_BIST_ADDR[6] A_ADDR[7] A_BIST_ADDR[7] A_CLK A_REN A_WEN A_MEN A_DLY A_BIST_EN
+ A_BIST_CLK A_BIST_REN A_BIST_WEN A_BIST_MEN
.ends

* Black-box entry subcircuit for sg13cmos5l_inv_16 abstract view
.subckt sg13cmos5l_inv_16 Y A VDD VSS
.ends

.subckt psum_requant_container VDD VSS act_out[0] act_out[1] act_out[2] act_out[3]
+ act_out[4] act_out[5] act_out[6] act_out[7] bank_A_addr[0] bank_A_addr[1] bank_A_addr[2]
+ bank_A_addr[3] bank_A_addr[4] bank_A_addr[5] bank_A_addr[6] bank_A_addr[7] bank_A_rdata[0]
+ bank_A_rdata[10] bank_A_rdata[11] bank_A_rdata[12] bank_A_rdata[13] bank_A_rdata[14]
+ bank_A_rdata[15] bank_A_rdata[16] bank_A_rdata[17] bank_A_rdata[18] bank_A_rdata[19]
+ bank_A_rdata[1] bank_A_rdata[20] bank_A_rdata[21] bank_A_rdata[22] bank_A_rdata[23]
+ bank_A_rdata[24] bank_A_rdata[25] bank_A_rdata[26] bank_A_rdata[27] bank_A_rdata[28]
+ bank_A_rdata[29] bank_A_rdata[2] bank_A_rdata[30] bank_A_rdata[31] bank_A_rdata[3]
+ bank_A_rdata[4] bank_A_rdata[5] bank_A_rdata[6] bank_A_rdata[7] bank_A_rdata[8]
+ bank_A_rdata[9] bank_A_wdata[0] bank_A_wdata[10] bank_A_wdata[11] bank_A_wdata[12]
+ bank_A_wdata[13] bank_A_wdata[14] bank_A_wdata[15] bank_A_wdata[16] bank_A_wdata[17]
+ bank_A_wdata[18] bank_A_wdata[19] bank_A_wdata[1] bank_A_wdata[20] bank_A_wdata[21]
+ bank_A_wdata[22] bank_A_wdata[23] bank_A_wdata[24] bank_A_wdata[25] bank_A_wdata[26]
+ bank_A_wdata[27] bank_A_wdata[28] bank_A_wdata[29] bank_A_wdata[2] bank_A_wdata[30]
+ bank_A_wdata[31] bank_A_wdata[3] bank_A_wdata[4] bank_A_wdata[5] bank_A_wdata[6]
+ bank_A_wdata[7] bank_A_wdata[8] bank_A_wdata[9] bank_A_we bank_B_addr[0] bank_B_addr[1]
+ bank_B_addr[2] bank_B_addr[3] bank_B_addr[4] bank_B_addr[5] bank_B_addr[6] bank_B_addr[7]
+ bank_B_rdata[0] bank_B_rdata[10] bank_B_rdata[11] bank_B_rdata[12] bank_B_rdata[13]
+ bank_B_rdata[14] bank_B_rdata[15] bank_B_rdata[16] bank_B_rdata[17] bank_B_rdata[18]
+ bank_B_rdata[19] bank_B_rdata[1] bank_B_rdata[20] bank_B_rdata[21] bank_B_rdata[22]
+ bank_B_rdata[23] bank_B_rdata[24] bank_B_rdata[25] bank_B_rdata[26] bank_B_rdata[27]
+ bank_B_rdata[28] bank_B_rdata[29] bank_B_rdata[2] bank_B_rdata[30] bank_B_rdata[31]
+ bank_B_rdata[3] bank_B_rdata[4] bank_B_rdata[5] bank_B_rdata[6] bank_B_rdata[7]
+ bank_B_rdata[8] bank_B_rdata[9] bank_B_wdata[0] bank_B_wdata[10] bank_B_wdata[11]
+ bank_B_wdata[12] bank_B_wdata[13] bank_B_wdata[14] bank_B_wdata[15] bank_B_wdata[16]
+ bank_B_wdata[17] bank_B_wdata[18] bank_B_wdata[19] bank_B_wdata[1] bank_B_wdata[20]
+ bank_B_wdata[21] bank_B_wdata[22] bank_B_wdata[23] bank_B_wdata[24] bank_B_wdata[25]
+ bank_B_wdata[26] bank_B_wdata[27] bank_B_wdata[28] bank_B_wdata[29] bank_B_wdata[2]
+ bank_B_wdata[30] bank_B_wdata[31] bank_B_wdata[3] bank_B_wdata[4] bank_B_wdata[5]
+ bank_B_wdata[6] bank_B_wdata[7] bank_B_wdata[8] bank_B_wdata[9] bank_B_we clk_i
+ psum_lut_en quant_cfg[0] quant_cfg[10] quant_cfg[11] quant_cfg[12] quant_cfg[13]
+ quant_cfg[14] quant_cfg[15] quant_cfg[16] quant_cfg[17] quant_cfg[18] quant_cfg[19]
+ quant_cfg[1] quant_cfg[20] quant_cfg[21] quant_cfg[22] quant_cfg[23] quant_cfg[24]
+ quant_cfg[25] quant_cfg[26] quant_cfg[27] quant_cfg[28] quant_cfg[29] quant_cfg[2]
+ quant_cfg[3] quant_cfg[4] quant_cfg[5] quant_cfg[6] quant_cfg[7] quant_cfg[8] quant_cfg[9]
+ rst_n
XFILLER_79_380 VDD VSS sg13cmos5l_decap_8
XFILLER_39_266 VDD VSS sg13cmos5l_decap_8
XFILLER_54_225 VDD VSS sg13cmos5l_decap_8
XFILLER_55_759 VDD VSS sg13cmos5l_decap_8
XFILLER_82_556 VDD VSS sg13cmos5l_fill_2
XFILLER_35_450 VDD VSS sg13cmos5l_fill_1
X_6914_ _7132_/A _6996_/A _7069_/A _6913_/Y VDD VSS sg13cmos5l_o21ai_1
XFILLER_50_431 VDD VSS sg13cmos5l_fill_1
X_6845_ _6845_/Y _6996_/A _6845_/B VDD VSS sg13cmos5l_nor2_1
X_3988_ _4014_/B _3988_/A _3986_/A VDD VSS sg13cmos5l_nor2b_1
X_6776_ _6776_/X _6762_/Y _6900_/C _6775_/Y VDD VSS sg13cmos5l_a21o_1
XFILLER_50_497 VDD VSS sg13cmos5l_fill_2
X_5727_ _5782_/B _5727_/A _5737_/A VDD VSS sg13cmos5l_xor2_1
X_5658_ _5659_/A _5658_/A _5677_/B VDD VSS sg13cmos5l_xnor2_1
X_5589_ _5590_/B _5589_/A _5588_/Y VDD VSS sg13cmos5l_nor2b_1
X_4609_ _4668_/A _4726_/B _4609_/B VDD VSS sg13cmos5l_nor2_1
X_7328_ _7328_/Y _7328_/A _7343_/A VDD VSS sg13cmos5l_nor2_1
X_7259_ _7542_/B _7259_/A _7292_/A VDD VSS sg13cmos5l_nand2_1
XFILLER_77_339 VDD VSS sg13cmos5l_fill_2
XFILLER_46_704 VDD VSS sg13cmos5l_fill_2
XFILLER_42_932 VDD VSS sg13cmos5l_fill_2
XFILLER_42_921 VDD VSS sg13cmos5l_decap_8
XFILLER_54_770 VDD VSS sg13cmos5l_fill_2
XFILLER_54_792 VDD VSS sg13cmos5l_decap_8
XFILLER_53_280 VDD VSS sg13cmos5l_fill_1
XFILLER_41_475 VDD VSS sg13cmos5l_fill_1
XFILLER_42_73 VDD VSS sg13cmos5l_decap_8
XFILLER_3_12 VDD VSS sg13cmos5l_decap_8
XFILLER_69_829 VDD VSS sg13cmos5l_fill_2
XFILLER_68_317 VDD VSS sg13cmos5l_decap_8
Xbank_A_sram.gen_ihp_256x32.u_sram_256x32_396 bank_A_sram.gen_ihp_256x32.u_sram_256x32_396/L_LO
+ VDD VSS sg13cmos5l_tielo
XFILLER_67_70 VDD VSS sg13cmos5l_decap_4
XFILLER_36_214 VDD VSS sg13cmos5l_decap_8
XFILLER_64_523 VDD VSS sg13cmos5l_fill_2
XFILLER_64_545 VDD VSS sg13cmos5l_fill_1
X_4960_ _5030_/A _4958_/Y _4899_/B _4959_/Y VDD VSS sg13cmos5l_o21ai_1
XFILLER_52_729 VDD VSS sg13cmos5l_decap_8
X_4891_ _4939_/A _5206_/B _5190_/A _4890_/Y VDD VSS sg13cmos5l_a21o_1
XFILLER_44_291 VDD VSS sg13cmos5l_decap_8
X_6630_ _6631_/A _6630_/A _6630_/B VDD VSS sg13cmos5l_nor2_1
X_6561_ _6561_/Y _6567_/A _6561_/B VDD VSS sg13cmos5l_nand2_1
X_5512_ _5512_/Y _5512_/A _5512_/B VDD VSS sg13cmos5l_nor2_1
X_6492_ _6508_/A _6492_/A _6491_/A VDD VSS sg13cmos5l_nor2b_2
X_5443_ _5443_/X _5443_/A VDD VSS sg13cmos5l_buf_1
X_5374_ _5374_/X _5374_/A _5374_/B VDD VSS sg13cmos5l_and2_1
X_4325_ _4328_/A _3972_/A _4688_/A _4387_/A VDD VSS sg13cmos5l_a21oi_1
X_7113_ _7264_/B _7112_/B _6831_/A _7112_/Y VDD VSS sg13cmos5l_o21ai_1
XFILLER_68_851 VDD VSS sg13cmos5l_decap_8
X_4256_ _4289_/A _4210_/A _4210_/B _4255_/Y VDD VSS sg13cmos5l_a21o_1
X_7044_ _7087_/A _7044_/A VDD VSS sg13cmos5l_buf_1
X_4187_ _4188_/A _4187_/A _4234_/A VDD VSS sg13cmos5l_xnor2_1
XFILLER_55_512 VDD VSS sg13cmos5l_fill_2
XFILLER_82_386 VDD VSS sg13cmos5l_fill_1
XFILLER_70_537 VDD VSS sg13cmos5l_fill_2
XFILLER_51_762 VDD VSS sg13cmos5l_fill_1
X_6828_ _6829_/B _6826_/Y _6827_/Y _6957_/S VDD VSS sg13cmos5l_mux2_1
XFILLER_12_21 VDD VSS sg13cmos5l_decap_8
X_6759_ _6759_/X _6759_/A _6960_/B VDD VSS sg13cmos5l_and2_1
XFILLER_88_25 VDD VSS sg13cmos5l_decap_4
XFILLER_46_512 VDD VSS sg13cmos5l_decap_8
XFILLER_58_372 VDD VSS sg13cmos5l_decap_4
XFILLER_59_895 VDD VSS sg13cmos5l_decap_4
XFILLER_73_342 VDD VSS sg13cmos5l_fill_1
XFILLER_74_887 VDD VSS sg13cmos5l_fill_2
XFILLER_73_386 VDD VSS sg13cmos5l_fill_1
XFILLER_73_364 VDD VSS sg13cmos5l_decap_4
XFILLER_37_95 VDD VSS sg13cmos5l_decap_8
XFILLER_46_578 VDD VSS sg13cmos5l_fill_2
XFILLER_61_504 VDD VSS sg13cmos5l_fill_2
XFILLER_61_559 VDD VSS sg13cmos5l_fill_1
XFILLER_53_72 VDD VSS sg13cmos5l_fill_1
XFILLER_41_272 VDD VSS sg13cmos5l_fill_1
XFILLER_41_261 VDD VSS sg13cmos5l_fill_1
XFILLER_38_4 VDD VSS sg13cmos5l_decap_8
X_4110_ _4112_/A _4110_/A _4110_/B VDD VSS sg13cmos5l_nand2_1
X_5090_ _5162_/B _5157_/A _5090_/B VDD VSS sg13cmos5l_xnor2_1
X_4041_ _7664_/D _4100_/A _4100_/B VDD VSS sg13cmos5l_xor2_1
XFILLER_68_158 VDD VSS sg13cmos5l_fill_1
XFILLER_65_854 VDD VSS sg13cmos5l_decap_8
X_5992_ _5993_/B _5992_/A _6019_/A VDD VSS sg13cmos5l_xnor2_1
X_4943_ _5269_/A _4943_/A VDD VSS sg13cmos5l_buf_1
XFILLER_80_879 VDD VSS sg13cmos5l_fill_1
X_7662_ _7662_/Q clkload8/A _7662_/D fanout388/X VDD VSS sg13cmos5l_dfrbpq_1
X_6613_ _6615_/A _6613_/A VDD VSS sg13cmos5l_inv_1
X_4874_ _4924_/A _5442_/A _4874_/B VDD VSS sg13cmos5l_xnor2_1
X_7593_ _7596_/B _7628_/A _7593_/B VDD VSS sg13cmos5l_nand2_2
X_6544_ _6554_/A _6544_/A _6589_/A VDD VSS sg13cmos5l_nand2_1
X_6475_ _6475_/Y _6476_/B _6476_/A VDD VSS sg13cmos5l_nor2_1
X_5426_ _5542_/B _5426_/A _5426_/B VDD VSS sg13cmos5l_nand2_1
X_5357_ _5358_/A _5357_/A _5357_/B VDD VSS sg13cmos5l_xor2_1
X_5288_ _5351_/A _5288_/A _5288_/B VDD VSS sg13cmos5l_nand2_1
X_4308_ _4309_/B _3964_/C _4429_/A _3965_/B _4430_/A VDD VSS sg13cmos5l_a22oi_1
X_4239_ _4239_/Y _4243_/B _4243_/C VDD VSS sg13cmos5l_nand2_1
X_7027_ _7027_/Y _7027_/A VDD VSS sg13cmos5l_inv_1
XFILLER_74_49 VDD VSS sg13cmos5l_decap_8
XFILLER_56_876 VDD VSS sg13cmos5l_decap_4
XFILLER_43_504 VDD VSS sg13cmos5l_fill_2
XFILLER_56_887 VDD VSS sg13cmos5l_fill_2
XFILLER_56_898 VDD VSS sg13cmos5l_fill_1
XFILLER_82_172 VDD VSS sg13cmos5l_decap_4
XFILLER_43_548 VDD VSS sg13cmos5l_decap_8
XFILLER_71_879 VDD VSS sg13cmos5l_decap_8
XFILLER_70_378 VDD VSS sg13cmos5l_fill_2
XFILLER_66_607 VDD VSS sg13cmos5l_decap_8
XFILLER_74_662 VDD VSS sg13cmos5l_fill_1
XFILLER_47_887 VDD VSS sg13cmos5l_fill_2
XFILLER_62_824 VDD VSS sg13cmos5l_decap_8
XFILLER_62_857 VDD VSS sg13cmos5l_decap_8
XFILLER_61_378 VDD VSS sg13cmos5l_fill_1
XFILLER_80_81 VDD VSS sg13cmos5l_decap_8
X_4590_ _4590_/Y _4590_/A _4590_/B VDD VSS sg13cmos5l_nor2_1
X_6260_ _6275_/A _6561_/B _6416_/A VDD VSS sg13cmos5l_nand2_1
X_5211_ _5212_/B _5266_/A _5266_/B VDD VSS sg13cmos5l_xor2_1
X_6191_ _6191_/Y _6209_/A1 _6189_/Y _6190_/Y VDD VSS sg13cmos5l_a21oi_1
XFILLER_43_2 VDD VSS sg13cmos5l_fill_1
X_5142_ _5142_/X _5206_/B VDD VSS sg13cmos5l_buf_1
XFILLER_69_456 VDD VSS sg13cmos5l_decap_4
XFILLER_57_618 VDD VSS sg13cmos5l_fill_1
X_5073_ _5086_/A _5331_/A _5073_/B VDD VSS sg13cmos5l_xnor2_1
XFILLER_57_629 VDD VSS sg13cmos5l_fill_1
X_4024_ _4025_/B _4128_/A _4172_/B _4024_/C VDD VSS sg13cmos5l_nor3_1
XFILLER_37_364 VDD VSS sg13cmos5l_fill_2
XFILLER_53_813 VDD VSS sg13cmos5l_fill_2
XFILLER_64_161 VDD VSS sg13cmos5l_decap_8
XFILLER_53_868 VDD VSS sg13cmos5l_fill_1
X_5975_ _5975_/Y _5975_/A _5956_/A VDD VSS sg13cmos5l_nor2b_1
XFILLER_52_367 VDD VSS sg13cmos5l_fill_1
XFILLER_52_356 VDD VSS sg13cmos5l_fill_1
XFILLER_100_14 VDD VSS sg13cmos5l_decap_8
X_7714_ _7714_/Q _7724_/CLK _7714_/D fanout384/X VDD VSS sg13cmos5l_dfrbpq_1
X_4926_ _4927_/B _4926_/A _4982_/A VDD VSS sg13cmos5l_xnor2_1
X_7645_ _7724_/D _7658_/B _7645_/B VDD VSS sg13cmos5l_nand2_2
X_4857_ _4904_/A _5048_/A _4915_/B VDD VSS sg13cmos5l_xnor2_1
XFILLER_60_29 VDD VSS sg13cmos5l_fill_2
X_7576_ _7623_/B _7576_/A _7576_/B VDD VSS sg13cmos5l_xnor2_1
X_6527_ _6527_/X _6527_/A VDD VSS sg13cmos5l_buf_2
X_4788_ _4847_/A _4728_/B _4729_/A _4787_/Y VDD VSS sg13cmos5l_o21ai_1
X_6458_ _6461_/A _6456_/Y _6468_/A VDD VSS sg13cmos5l_nand2b_1
X_5409_ _5425_/A _5409_/A _5409_/B VDD VSS sg13cmos5l_nand2_1
X_6389_ _6400_/A _6389_/A _6389_/B VDD VSS sg13cmos5l_nand2_1
XFILLER_85_15 VDD VSS sg13cmos5l_decap_8
XFILLER_48_618 VDD VSS sg13cmos5l_fill_1
XFILLER_75_426 VDD VSS sg13cmos5l_decap_8
XFILLER_75_448 VDD VSS sg13cmos5l_decap_8
XFILLER_71_665 VDD VSS sg13cmos5l_decap_8
XFILLER_50_40 VDD VSS sg13cmos5l_fill_2
XFILLER_78_220 VDD VSS sg13cmos5l_decap_8
XFILLER_66_415 VDD VSS sg13cmos5l_fill_2
XFILLER_82_919 VDD VSS sg13cmos5l_decap_8
XFILLER_78_297 VDD VSS sg13cmos5l_decap_8
XFILLER_81_429 VDD VSS sg13cmos5l_decap_8
XFILLER_35_824 VDD VSS sg13cmos5l_fill_1
XFILLER_74_470 VDD VSS sg13cmos5l_decap_8
XFILLER_35_846 VDD VSS sg13cmos5l_fill_2
XFILLER_62_610 VDD VSS sg13cmos5l_fill_2
XFILLER_62_643 VDD VSS sg13cmos5l_fill_2
XFILLER_62_665 VDD VSS sg13cmos5l_fill_1
X_5760_ _5761_/B _5505_/X _5941_/A2 _5949_/B1 _5941_/B2 VDD VSS sg13cmos5l_a22oi_1
XFILLER_61_186 VDD VSS sg13cmos5l_decap_8
XFILLER_61_175 VDD VSS sg13cmos5l_fill_2
X_5691_ _5739_/A _5639_/B _5639_/A _5690_/X VDD VSS sg13cmos5l_a21oi_1
X_4711_ _4712_/B _4711_/A _4779_/B VDD VSS sg13cmos5l_xor2_1
X_4642_ _4643_/B _4750_/A _5199_/A _4688_/A _5200_/A VDD VSS sg13cmos5l_a22oi_1
X_7430_ _7585_/A _7430_/A VDD VSS sg13cmos5l_buf_2
X_7361_ _7368_/A _7361_/A _7513_/B _7514_/B VDD VSS sg13cmos5l_nand3_1
X_4573_ _4580_/A _5060_/A _4573_/B VDD VSS sg13cmos5l_xnor2_1
X_7292_ _7554_/B _7292_/A _7307_/A VDD VSS sg13cmos5l_xnor2_1
X_6312_ _6611_/C _6915_/A _6355_/A _6548_/C VDD VSS sg13cmos5l_nor3_1
X_6243_ _6697_/A _6353_/A VDD VSS sg13cmos5l_inv_1
X_6174_ _6176_/A _6175_/B _6175_/C _6175_/A VDD VSS sg13cmos5l_nor3_1
XFILLER_58_905 VDD VSS sg13cmos5l_fill_1
X_5125_ _5126_/B _5125_/A _5175_/A VDD VSS sg13cmos5l_xnor2_1
X_5056_ _5057_/B _5056_/A _5113_/A VDD VSS sg13cmos5l_xnor2_1
X_4007_ _4008_/B _3963_/A _4529_/A _3937_/A _4530_/A VDD VSS sg13cmos5l_a22oi_1
XFILLER_37_172 VDD VSS sg13cmos5l_decap_8
XFILLER_53_621 VDD VSS sg13cmos5l_fill_2
XFILLER_65_492 VDD VSS sg13cmos5l_fill_2
XFILLER_80_462 VDD VSS sg13cmos5l_decap_8
XFILLER_52_131 VDD VSS sg13cmos5l_fill_1
XFILLER_52_153 VDD VSS sg13cmos5l_decap_8
XFILLER_40_315 VDD VSS sg13cmos5l_fill_1
X_5958_ _5999_/A _5878_/A _5947_/B _5957_/Y VDD VSS sg13cmos5l_o21ai_1
X_4909_ _4974_/A _4909_/A _4914_/A VDD VSS sg13cmos5l_xnor2_1
XFILLER_52_197 VDD VSS sg13cmos5l_decap_4
X_5889_ _5936_/A _5889_/A _5889_/B _5889_/C VDD VSS sg13cmos5l_nand3_1
Xrebuffer833 _6786_/B _6309_/A VDD VSS sg13cmos5l_buf_1
X_7628_ _7629_/D _7628_/A _7592_/C VDD VSS sg13cmos5l_nor2b_1
X_7559_ _7616_/A _7559_/A _7559_/B VDD VSS sg13cmos5l_xnor2_1
Xrebuffer844 _6764_/B _6600_/A VDD VSS sg13cmos5l_buf_1
XFILLER_105_4 VDD VSS sg13cmos5l_decap_8
XFILLER_96_25 VDD VSS sg13cmos5l_decap_4
XFILLER_76_702 VDD VSS sg13cmos5l_fill_2
XFILLER_48_404 VDD VSS sg13cmos5l_decap_8
XFILLER_75_245 VDD VSS sg13cmos5l_fill_1
XFILLER_75_223 VDD VSS sg13cmos5l_fill_1
XFILLER_48_437 VDD VSS sg13cmos5l_fill_1
XFILLER_63_407 VDD VSS sg13cmos5l_decap_8
XFILLER_75_289 VDD VSS sg13cmos5l_fill_2
XFILLER_56_470 VDD VSS sg13cmos5l_fill_1
XFILLER_56_481 VDD VSS sg13cmos5l_fill_1
XFILLER_43_131 VDD VSS sg13cmos5l_decap_8
XFILLER_44_665 VDD VSS sg13cmos5l_fill_2
XFILLER_45_95 VDD VSS sg13cmos5l_decap_4
XFILLER_40_871 VDD VSS sg13cmos5l_decap_8
XANTENNA_5 _7713_/D VDD VSS sg13cmos5l_antennanp
XFILLER_20_4 VDD VSS sg13cmos5l_decap_8
XFILLER_82_716 VDD VSS sg13cmos5l_decap_4
XFILLER_66_278 VDD VSS sg13cmos5l_fill_2
XFILLER_81_226 VDD VSS sg13cmos5l_decap_8
XFILLER_75_790 VDD VSS sg13cmos5l_fill_2
X_6930_ _6931_/A _6957_/S _6872_/A _6929_/Y VDD VSS sg13cmos5l_o21ai_1
X_6861_ _6862_/B _6861_/A _6861_/B VDD VSS sg13cmos5l_nand2_1
X_5812_ _5876_/B _5810_/B _5811_/A _5810_/Y _5811_/Y VDD VSS sg13cmos5l_a22oi_1
X_6792_ _6792_/Y _6813_/S _6970_/A VDD VSS sg13cmos5l_nor2_1
XFILLER_50_668 VDD VSS sg13cmos5l_fill_1
X_5743_ _5773_/A _5741_/Y _5721_/A _5742_/Y VDD VSS sg13cmos5l_a21oi_1
X_5674_ _5736_/A _5674_/A _5674_/B _5674_/C VDD VSS sg13cmos5l_nand3_1
X_4625_ _4626_/B _4625_/A _4672_/A VDD VSS sg13cmos5l_xnor2_1
X_7413_ _7414_/C _7413_/A _7413_/B VDD VSS sg13cmos5l_nor2_1
X_7344_ _7344_/Y _7130_/Y _7394_/A2 _7377_/B VDD VSS sg13cmos5l_a21oi_1
X_4556_ _4604_/A _4854_/A _4615_/B VDD VSS sg13cmos5l_xnor2_1
X_4487_ _4487_/X _4494_/B VDD VSS sg13cmos5l_buf_1
X_7275_ _7343_/A _7275_/A VDD VSS sg13cmos5l_buf_1
X_6226_ _6226_/Y _6212_/X _6204_/Y _6225_/Y VDD VSS sg13cmos5l_o21ai_1
X_6157_ _7704_/D _6157_/A _6157_/B VDD VSS sg13cmos5l_xor2_1
XFILLER_58_735 VDD VSS sg13cmos5l_fill_1
X_5108_ _5234_/B _5108_/A _5108_/B VDD VSS sg13cmos5l_and2_1
XFILLER_72_204 VDD VSS sg13cmos5l_fill_2
X_6088_ _6120_/A _6108_/B _6088_/B VDD VSS sg13cmos5l_xnor2_1
X_5039_ _7682_/D _5105_/B _5039_/B VDD VSS sg13cmos5l_xor2_1
XFILLER_82_16 VDD VSS sg13cmos5l_decap_8
XFILLER_81_793 VDD VSS sg13cmos5l_fill_1
Xrebuffer630 rebuffer630/X rebuffer631/X VDD VSS sg13cmos5l_buf_1
Xrebuffer641 rebuffer641/X _6991_/B VDD VSS sg13cmos5l_buf_1
Xrebuffer663 rebuffer663/X rebuffer664/X VDD VSS sg13cmos5l_buf_1
Xrebuffer674 rebuffer674/X rebuffer675/X VDD VSS sg13cmos5l_buf_1
Xrebuffer685 rebuffer685/X rebuffer686/X VDD VSS sg13cmos5l_buf_1
Xrebuffer652 rebuffer652/X rebuffer653/X VDD VSS sg13cmos5l_buf_1
Xrebuffer696 rebuffer696/X _7375_/A VDD VSS sg13cmos5l_buf_1
XFILLER_76_510 VDD VSS sg13cmos5l_decap_4
XFILLER_49_713 VDD VSS sg13cmos5l_fill_1
Xbank_A_sram.gen_ihp_256x32.u_sram_256x32_556 bank_A_sram.gen_ihp_256x32.u_sram_256x32/A_BM[8]
+ VDD VSS sg13cmos5l_tiehi
Xbank_A_sram.gen_ihp_256x32.u_sram_256x32_567 bank_A_sram.gen_ihp_256x32.u_sram_256x32_567/L_HI
+ VDD VSS sg13cmos5l_tiehi
Xbank_A_sram.gen_ihp_256x32.u_sram_256x32_578 bank_A_sram.gen_ihp_256x32.u_sram_256x32_578/L_HI
+ VDD VSS sg13cmos5l_tiehi
XFILLER_49_746 VDD VSS sg13cmos5l_fill_1
XFILLER_56_50 VDD VSS sg13cmos5l_fill_1
XFILLER_60_933 VDD VSS sg13cmos5l_fill_1
Xbank_B_sram.gen_ihp_256x32.u_sram_256x32_582 bank_B_sram.gen_ihp_256x32.u_sram_256x32/A_BM[0]
+ VDD VSS sg13cmos5l_tiehi
Xbank_B_sram.gen_ihp_256x32.u_sram_256x32_593 bank_B_sram.gen_ihp_256x32.u_sram_256x32_593/L_HI
+ VDD VSS sg13cmos5l_tiehi
X_4410_ _4475_/B _4410_/A _4476_/B VDD VSS sg13cmos5l_xnor2_1
X_5390_ _5438_/A _5341_/B _5341_/A _5389_/Y VDD VSS sg13cmos5l_a21oi_1
X_4341_ _4343_/C _4357_/A _4356_/A VDD VSS sg13cmos5l_xnor2_1
X_4272_ _4282_/A _4272_/A _4272_/B VDD VSS sg13cmos5l_xnor2_1
Xfanout309 _6900_/C _7036_/A VDD VSS sg13cmos5l_buf_1
X_7060_ _7060_/Y _7058_/Y _7111_/A _7059_/Y VDD VSS sg13cmos5l_a21oi_1
XFILLER_67_510 VDD VSS sg13cmos5l_decap_8
X_6011_ _6012_/B _5966_/B _6128_/A _6010_/X VDD VSS sg13cmos5l_a21o_1
XFILLER_39_245 VDD VSS sg13cmos5l_decap_8
XFILLER_82_513 VDD VSS sg13cmos5l_fill_1
XFILLER_54_204 VDD VSS sg13cmos5l_decap_4
X_6913_ _6913_/Y _7052_/A _6913_/B VDD VSS sg13cmos5l_nand2_1
XFILLER_54_259 VDD VSS sg13cmos5l_fill_1
XFILLER_54_248 VDD VSS sg13cmos5l_decap_8
XFILLER_63_771 VDD VSS sg13cmos5l_fill_1
XFILLER_50_410 VDD VSS sg13cmos5l_fill_1
X_6844_ _6845_/B _6841_/X _6813_/S _6843_/X VDD VSS sg13cmos5l_a21oi_1
XFILLER_62_292 VDD VSS sg13cmos5l_fill_2
X_3987_ _4015_/B _3987_/A _3987_/B VDD VSS sg13cmos5l_nor2_1
X_6775_ _6775_/Y _6937_/A _6775_/B VDD VSS sg13cmos5l_nor2_1
X_5726_ _5737_/A _5775_/A _5726_/B VDD VSS sg13cmos5l_xnor2_1
X_5657_ _5677_/B _5657_/A _5657_/B VDD VSS sg13cmos5l_xnor2_1
X_5588_ _5588_/Y _5588_/A _5709_/B VDD VSS sg13cmos5l_nand2_1
X_4608_ _4609_/B _4550_/A _4551_/A _4607_/Y VDD VSS sg13cmos5l_a21oi_1
XFILLER_7_8 VDD VSS sg13cmos5l_decap_8
X_7327_ _7328_/A _7327_/A _7327_/B VDD VSS sg13cmos5l_nor2_1
X_4539_ _4539_/X _4539_/A _4539_/B VDD VSS sg13cmos5l_and2_1
X_7258_ _7260_/A _7258_/A _7542_/A _7543_/B VDD VSS sg13cmos5l_nand3_1
XFILLER_77_329 VDD VSS sg13cmos5l_decap_4
X_6209_ _6209_/Y _6209_/A1 _6207_/Y _6208_/Y VDD VSS sg13cmos5l_a21oi_1
XFILLER_58_543 VDD VSS sg13cmos5l_decap_8
X_7189_ _7297_/A _7189_/A VDD VSS sg13cmos5l_buf_1
XFILLER_93_15 VDD VSS sg13cmos5l_decap_8
XFILLER_58_565 VDD VSS sg13cmos5l_decap_8
XFILLER_46_738 VDD VSS sg13cmos5l_decap_8
XFILLER_58_587 VDD VSS sg13cmos5l_decap_8
XFILLER_54_760 VDD VSS sg13cmos5l_decap_4
XFILLER_41_421 VDD VSS sg13cmos5l_decap_8
XFILLER_49_532 VDD VSS sg13cmos5l_fill_2
XFILLER_49_554 VDD VSS sg13cmos5l_decap_8
Xbank_A_sram.gen_ihp_256x32.u_sram_256x32_397 bank_A_sram.gen_ihp_256x32.u_sram_256x32_397/L_LO
+ VDD VSS sg13cmos5l_tielo
XFILLER_64_579 VDD VSS sg13cmos5l_fill_1
X_4890_ _4890_/Y _4890_/A _4890_/B VDD VSS sg13cmos5l_nor2_1
X_6560_ _6567_/A _6560_/A _6560_/B VDD VSS sg13cmos5l_nor2_2
XFILLER_73_2 VDD VSS sg13cmos5l_fill_1
X_5511_ _5566_/B _5511_/A _5511_/B VDD VSS sg13cmos5l_xor2_1
X_6491_ _6491_/Y _6491_/A _6492_/A VDD VSS sg13cmos5l_nor2b_1
X_5442_ _5897_/B _5442_/A VDD VSS sg13cmos5l_buf_1
X_5373_ _5376_/A _5429_/S _5373_/B VDD VSS sg13cmos5l_xnor2_1
XFILLER_59_0 VDD VSS sg13cmos5l_fill_2
X_4324_ _4688_/A _4324_/A VDD VSS sg13cmos5l_buf_1
X_7112_ _7112_/Y _7112_/A _7112_/B VDD VSS sg13cmos5l_nand2_1
X_7043_ _7097_/A _7043_/A _7043_/B VDD VSS sg13cmos5l_nand2_2
X_4255_ _4255_/Y _4255_/A _4211_/B VDD VSS sg13cmos5l_nor2b_1
X_4186_ _4187_/A _4236_/B _4235_/A VDD VSS sg13cmos5l_xnor2_1
XFILLER_103_25 VDD VSS sg13cmos5l_decap_4
XFILLER_82_321 VDD VSS sg13cmos5l_decap_8
XFILLER_67_395 VDD VSS sg13cmos5l_decap_8
XFILLER_43_708 VDD VSS sg13cmos5l_decap_8
XFILLER_51_741 VDD VSS sg13cmos5l_fill_2
X_6827_ _6827_/Y _6827_/A _6827_/B VDD VSS sg13cmos5l_xnor2_1
X_6758_ _6968_/B _6918_/B VDD VSS sg13cmos5l_buf_1
X_5709_ _5711_/A _5710_/A _5709_/B VDD VSS sg13cmos5l_nand2b_1
X_6689_ _6696_/A _6689_/A _6690_/A VDD VSS sg13cmos5l_nor2b_1
XFILLER_78_638 VDD VSS sg13cmos5l_fill_2
XFILLER_59_841 VDD VSS sg13cmos5l_fill_1
XFILLER_58_340 VDD VSS sg13cmos5l_fill_2
XFILLER_59_874 VDD VSS sg13cmos5l_decap_8
XFILLER_74_822 VDD VSS sg13cmos5l_decap_8
XFILLER_73_310 VDD VSS sg13cmos5l_fill_2
XFILLER_74_844 VDD VSS sg13cmos5l_fill_2
XFILLER_37_74 VDD VSS sg13cmos5l_decap_8
XFILLER_46_546 VDD VSS sg13cmos5l_fill_1
XFILLER_53_95 VDD VSS sg13cmos5l_fill_2
X_4040_ _4100_/B _4102_/B _4040_/B VDD VSS sg13cmos5l_xor2_1
XFILLER_49_340 VDD VSS sg13cmos5l_fill_2
XFILLER_76_170 VDD VSS sg13cmos5l_decap_4
XFILLER_76_181 VDD VSS sg13cmos5l_fill_2
XFILLER_37_535 VDD VSS sg13cmos5l_decap_8
XFILLER_65_844 VDD VSS sg13cmos5l_decap_4
X_5991_ _6019_/A _5991_/A _5991_/B VDD VSS sg13cmos5l_nor2_1
X_4942_ _4953_/A _5010_/A _4942_/B VDD VSS sg13cmos5l_xnor2_1
X_7661_ _7661_/Q clkload6/A _7661_/D fanout387/X VDD VSS sg13cmos5l_dfrbpq_1
X_6612_ _6612_/Y _6613_/A _6614_/A VDD VSS sg13cmos5l_nor2_1
X_4873_ _4874_/B _5430_/B1 _4751_/X _4811_/X _4752_/X VDD VSS sg13cmos5l_a22oi_1
X_7592_ _7593_/B _7626_/B _7592_/B _7592_/C VDD VSS sg13cmos5l_nor3_2
X_6543_ _6544_/A _6549_/B _6549_/A VDD VSS sg13cmos5l_xnor2_1
X_6474_ _6476_/B _6541_/A _6611_/C VDD VSS sg13cmos5l_nand2_1
X_5425_ _5426_/B _5425_/A _5425_/B VDD VSS sg13cmos5l_nand2_1
X_5356_ _5357_/B _5415_/A _5418_/B VDD VSS sg13cmos5l_xnor2_1
X_5287_ _5288_/B _5215_/A _5287_/B VDD VSS sg13cmos5l_nand2b_1
X_4307_ _4340_/A _4363_/B _4360_/B VDD VSS sg13cmos5l_xnor2_1
X_4238_ _4238_/Y _4234_/Y _4192_/A _4243_/A VDD VSS sg13cmos5l_a21oi_1
X_7026_ _7027_/A _6886_/A _6875_/X _7044_/A VDD VSS sg13cmos5l_mux2_1
XFILLER_59_148 VDD VSS sg13cmos5l_fill_2
XFILLER_68_671 VDD VSS sg13cmos5l_fill_2
XFILLER_68_660 VDD VSS sg13cmos5l_fill_1
X_4169_ _4511_/A _4169_/A VDD VSS sg13cmos5l_buf_4
XFILLER_74_17 VDD VSS sg13cmos5l_decap_8
XFILLER_56_844 VDD VSS sg13cmos5l_fill_1
XFILLER_82_195 VDD VSS sg13cmos5l_decap_4
XFILLER_71_858 VDD VSS sg13cmos5l_decap_8
XFILLER_43_527 VDD VSS sg13cmos5l_fill_2
XFILLER_51_593 VDD VSS sg13cmos5l_fill_1
XFILLER_99_25 VDD VSS sg13cmos5l_decap_4
XFILLER_78_402 VDD VSS sg13cmos5l_decap_4
XFILLER_78_435 VDD VSS sg13cmos5l_fill_1
XFILLER_78_424 VDD VSS sg13cmos5l_fill_2
XFILLER_47_844 VDD VSS sg13cmos5l_fill_2
XFILLER_47_855 VDD VSS sg13cmos5l_decap_8
XFILLER_58_181 VDD VSS sg13cmos5l_fill_2
XFILLER_46_354 VDD VSS sg13cmos5l_decap_4
XFILLER_46_387 VDD VSS sg13cmos5l_decap_8
XFILLER_62_836 VDD VSS sg13cmos5l_decap_8
XFILLER_62_847 VDD VSS sg13cmos5l_fill_1
XFILLER_61_357 VDD VSS sg13cmos5l_fill_2
XFILLER_80_60 VDD VSS sg13cmos5l_decap_8
XFILLER_42_593 VDD VSS sg13cmos5l_decap_8
XFILLER_80_93 VDD VSS sg13cmos5l_decap_4
X_5210_ _5266_/B _5586_/A _5210_/B VDD VSS sg13cmos5l_xnor2_1
X_6190_ _6190_/Y _6223_/A _6190_/B VDD VSS sg13cmos5l_nor2_1
X_5141_ _5152_/A _5331_/A _5141_/B VDD VSS sg13cmos5l_xnor2_1
XFILLER_69_446 VDD VSS sg13cmos5l_fill_2
X_5072_ _5073_/B _5190_/A _5199_/A _5131_/A _5200_/A VDD VSS sg13cmos5l_a22oi_1
X_4023_ _4024_/C _4262_/A VDD VSS sg13cmos5l_inv_1
XFILLER_38_811 VDD VSS sg13cmos5l_fill_2
XFILLER_38_844 VDD VSS sg13cmos5l_decap_8
XFILLER_38_899 VDD VSS sg13cmos5l_decap_8
XFILLER_37_343 VDD VSS sg13cmos5l_decap_8
XFILLER_53_836 VDD VSS sg13cmos5l_fill_2
XFILLER_53_847 VDD VSS sg13cmos5l_fill_1
XFILLER_64_195 VDD VSS sg13cmos5l_fill_2
X_7713_ _7713_/Q clkload4/A _7713_/D fanout382/X VDD VSS sg13cmos5l_dfrbpq_1
X_5974_ _6036_/A _5955_/B _5955_/A _5973_/Y VDD VSS sg13cmos5l_a21oi_1
XFILLER_61_891 VDD VSS sg13cmos5l_fill_2
X_4925_ _4982_/A _4881_/B _4881_/A _4924_/X VDD VSS sg13cmos5l_a21oi_1
X_7644_ _7645_/B _7657_/A _7644_/B VDD VSS sg13cmos5l_nand2_2
X_4856_ _4915_/B _4806_/B _4806_/A _4855_/Y VDD VSS sg13cmos5l_a21oi_1
X_7575_ _7576_/B _7575_/A _7575_/B VDD VSS sg13cmos5l_nand2_1
X_6526_ _6529_/A _6534_/B _6534_/A VDD VSS sg13cmos5l_xnor2_1
X_4787_ _4787_/Y _4724_/A _4726_/X _4724_/B VDD VSS sg13cmos5l_o21ai_1
XFILLER_107_8 VDD VSS sg13cmos5l_decap_8
X_6457_ _6468_/A _6457_/A _6457_/B _6457_/C VDD VSS sg13cmos5l_nand3_1
X_5408_ _5409_/B _5344_/A _5408_/B VDD VSS sg13cmos5l_nand2b_1
X_6388_ _6388_/Y _6389_/B _6389_/A VDD VSS sg13cmos5l_nor2_1
X_5339_ _5389_/B _5400_/A _5339_/B VDD VSS sg13cmos5l_xnor2_1
X_7009_ _7010_/A _7326_/A _7111_/A _7326_/B VDD VSS sg13cmos5l_nand3_1
XFILLER_47_129 VDD VSS sg13cmos5l_fill_1
XFILLER_43_313 VDD VSS sg13cmos5l_decap_8
XFILLER_43_302 VDD VSS sg13cmos5l_decap_4
XFILLER_43_335 VDD VSS sg13cmos5l_fill_2
XFILLER_52_891 VDD VSS sg13cmos5l_decap_8
XFILLER_59_50 VDD VSS sg13cmos5l_fill_1
XFILLER_78_276 VDD VSS sg13cmos5l_decap_8
XFILLER_66_449 VDD VSS sg13cmos5l_fill_2
XFILLER_81_408 VDD VSS sg13cmos5l_decap_8
XFILLER_75_60 VDD VSS sg13cmos5l_fill_1
XFILLER_47_663 VDD VSS sg13cmos5l_fill_1
XFILLER_47_674 VDD VSS sg13cmos5l_fill_2
XFILLER_47_685 VDD VSS sg13cmos5l_decap_8
XFILLER_61_143 VDD VSS sg13cmos5l_decap_8
XFILLER_50_828 VDD VSS sg13cmos5l_fill_1
XFILLER_98_4 VDD VSS sg13cmos5l_decap_8
X_5690_ _5690_/X _5690_/A _5690_/B VDD VSS sg13cmos5l_and2_1
X_4710_ _4779_/B _4710_/A _4710_/B VDD VSS sg13cmos5l_xor2_1
X_4641_ _4641_/X _4641_/A VDD VSS sg13cmos5l_buf_1
X_7360_ _7514_/B _7360_/A _7374_/B VDD VSS sg13cmos5l_nand2_1
X_4572_ _4573_/B _4859_/B1 _4996_/A _4799_/B1 _4997_/A VDD VSS sg13cmos5l_a22oi_1
X_6311_ _6548_/C _6768_/A _6720_/A VDD VSS sg13cmos5l_nand2_1
X_7291_ _7307_/A _6630_/A _7284_/Y _7290_/Y VDD VSS sg13cmos5l_o21ai_1
X_6242_ _6290_/C _6242_/A VDD VSS sg13cmos5l_buf_8
XFILLER_69_232 VDD VSS sg13cmos5l_fill_2
X_6173_ _6177_/A _6165_/A _6173_/B VDD VSS sg13cmos5l_nand2b_1
XFILLER_69_265 VDD VSS sg13cmos5l_fill_2
X_5124_ _5175_/A _5069_/B _5069_/A _5123_/X VDD VSS sg13cmos5l_a21oi_1
X_5055_ _5113_/A _5006_/B _5006_/A _5054_/X VDD VSS sg13cmos5l_a21oi_1
X_4006_ _4033_/A _3957_/X _4155_/A _4005_/Y VDD VSS sg13cmos5l_a21o_1
XFILLER_37_151 VDD VSS sg13cmos5l_decap_8
XFILLER_81_931 VDD VSS sg13cmos5l_fill_2
XFILLER_53_611 VDD VSS sg13cmos5l_fill_2
XFILLER_80_441 VDD VSS sg13cmos5l_decap_8
XFILLER_53_666 VDD VSS sg13cmos5l_decap_4
XFILLER_53_688 VDD VSS sg13cmos5l_decap_8
X_5957_ _5957_/Y _5917_/B _5957_/B VDD VSS sg13cmos5l_nand2b_1
XFILLER_40_349 VDD VSS sg13cmos5l_fill_2
X_4908_ _4914_/A _5048_/A _4968_/A VDD VSS sg13cmos5l_xnor2_1
X_5888_ _5890_/A _5888_/A1 _5889_/B _5889_/C VDD VSS sg13cmos5l_a21oi_1
X_7627_ _7629_/B _7627_/A _7627_/B VDD VSS sg13cmos5l_nor2_2
Xrebuffer834 rebuffer834/X _7217_/A VDD VSS sg13cmos5l_buf_1
X_4839_ _4840_/B _4839_/A _4839_/B VDD VSS sg13cmos5l_nand2_1
X_7558_ _7559_/B _7558_/A _7558_/B VDD VSS sg13cmos5l_nor2_1
Xrebuffer845 _6756_/B _6618_/A VDD VSS sg13cmos5l_buf_1
X_6509_ _6519_/A _6518_/B _6518_/C VDD VSS sg13cmos5l_nor2_1
XFILLER_20_11 VDD VSS sg13cmos5l_decap_8
X_7489_ _7489_/Y _7605_/C _7489_/B VDD VSS sg13cmos5l_xnor2_1
XFILLER_75_279 VDD VSS sg13cmos5l_fill_1
XFILLER_44_644 VDD VSS sg13cmos5l_decap_8
XFILLER_43_165 VDD VSS sg13cmos5l_decap_4
XFILLER_61_40 VDD VSS sg13cmos5l_fill_1
XFILLER_61_62 VDD VSS sg13cmos5l_decap_8
XANTENNA_6 _7714_/D VDD VSS sg13cmos5l_antennanp
XFILLER_66_235 VDD VSS sg13cmos5l_decap_8
XFILLER_66_268 VDD VSS sg13cmos5l_decap_4
XFILLER_82_739 VDD VSS sg13cmos5l_decap_8
XFILLER_81_205 VDD VSS sg13cmos5l_decap_8
XFILLER_35_622 VDD VSS sg13cmos5l_decap_8
XFILLER_35_633 VDD VSS sg13cmos5l_decap_4
X_6860_ _6862_/A _6860_/A _6860_/B VDD VSS sg13cmos5l_nand2_1
X_5811_ _5811_/Y _5811_/A _5811_/B VDD VSS sg13cmos5l_nor2_1
X_6791_ _6970_/A _6791_/A _6791_/B VDD VSS sg13cmos5l_xor2_1
XFILLER_50_625 VDD VSS sg13cmos5l_fill_1
X_5742_ _5742_/Y _5742_/A _5742_/B VDD VSS sg13cmos5l_nor2_1
X_5673_ _5675_/A _5673_/A1 _5674_/B _5674_/C VDD VSS sg13cmos5l_a21oi_1
X_4624_ _4672_/A _4580_/B _4580_/A _4623_/X VDD VSS sg13cmos5l_a21oi_1
X_7412_ _7413_/A _7407_/B _7570_/A _7424_/A VDD VSS sg13cmos5l_o21ai_1
X_7343_ _7343_/X _7343_/A VDD VSS sg13cmos5l_buf_1
X_4555_ _4615_/B _4504_/B _4505_/A _4502_/Y VDD VSS sg13cmos5l_a21oi_1
X_7274_ _7275_/A _7274_/A _7484_/B VDD VSS sg13cmos5l_nor2_1
X_4486_ _4542_/A _4486_/A _4486_/B VDD VSS sg13cmos5l_nand2_1
XFILLER_106_25 VDD VSS sg13cmos5l_decap_4
X_6225_ _6225_/Y _6227_/A _6225_/B VDD VSS sg13cmos5l_nand2_1
X_6156_ _6157_/B _6134_/B _6134_/A _6155_/X VDD VSS sg13cmos5l_a21o_1
X_5107_ _7683_/D _5107_/A _5107_/B VDD VSS sg13cmos5l_xnor2_1
XFILLER_58_758 VDD VSS sg13cmos5l_decap_4
XFILLER_45_408 VDD VSS sg13cmos5l_fill_1
X_6087_ _6088_/B _6123_/B _6107_/B VDD VSS sg13cmos5l_xnor2_1
X_5038_ _5105_/A _4975_/Y _4977_/A _5037_/Y VDD VSS sg13cmos5l_o21ai_1
XFILLER_81_772 VDD VSS sg13cmos5l_decap_8
X_6989_ _7043_/A _6989_/A _6989_/B VDD VSS sg13cmos5l_nand2_2
Xrebuffer631 rebuffer631/X rebuffer632/X VDD VSS sg13cmos5l_buf_1
Xrebuffer620 _7564_/B rebuffer684/X VDD VSS sg13cmos5l_buf_1
Xrebuffer642 _7638_/A _7043_/B VDD VSS sg13cmos5l_buf_1
Xrebuffer675 rebuffer675/X rebuffer676/X VDD VSS sg13cmos5l_buf_1
Xrebuffer664 rebuffer664/X rebuffer665/X VDD VSS sg13cmos5l_buf_1
Xrebuffer653 rebuffer653/X rebuffer654/X VDD VSS sg13cmos5l_buf_1
Xrebuffer686 rebuffer686/X rebuffer687/X VDD VSS sg13cmos5l_buf_1
Xrebuffer697 rebuffer697/X _6677_/A VDD VSS sg13cmos5l_buf_1
XFILLER_49_725 VDD VSS sg13cmos5l_decap_8
Xbank_A_sram.gen_ihp_256x32.u_sram_256x32_557 bank_A_sram.gen_ihp_256x32.u_sram_256x32/A_BM[9]
+ VDD VSS sg13cmos5l_tiehi
Xbank_A_sram.gen_ihp_256x32.u_sram_256x32_568 bank_A_sram.gen_ihp_256x32.u_sram_256x32_568/L_HI
+ VDD VSS sg13cmos5l_tiehi
Xbank_A_sram.gen_ihp_256x32.u_sram_256x32_579 bank_A_sram.gen_ihp_256x32.u_sram_256x32_579/L_HI
+ VDD VSS sg13cmos5l_tiehi
XFILLER_36_419 VDD VSS sg13cmos5l_decap_8
XFILLER_63_205 VDD VSS sg13cmos5l_fill_1
XFILLER_56_290 VDD VSS sg13cmos5l_fill_2
Xbank_B_sram.gen_ihp_256x32.u_sram_256x32_583 bank_B_sram.gen_ihp_256x32.u_sram_256x32/A_BM[1]
+ VDD VSS sg13cmos5l_tiehi
Xbank_B_sram.gen_ihp_256x32.u_sram_256x32_594 bank_B_sram.gen_ihp_256x32.u_sram_256x32_594/L_HI
+ VDD VSS sg13cmos5l_tiehi
XFILLER_72_83 VDD VSS sg13cmos5l_fill_1
XFILLER_75_6 VDD VSS sg13cmos5l_fill_1
X_4340_ _4356_/A _4340_/A _4340_/B VDD VSS sg13cmos5l_xor2_1
X_4271_ _4272_/B _4375_/A _3998_/X _4310_/A _4122_/X VDD VSS sg13cmos5l_a22oi_1
X_6010_ _6010_/X _6010_/A _6010_/B VDD VSS sg13cmos5l_and2_1
XFILLER_39_224 VDD VSS sg13cmos5l_decap_8
XFILLER_82_536 VDD VSS sg13cmos5l_decap_8
X_6912_ _7052_/A _6927_/B _6759_/A _6911_/Y VDD VSS sg13cmos5l_o21ai_1
X_6843_ _6843_/X _6843_/A _6849_/B VDD VSS sg13cmos5l_and2_1
X_3986_ _7662_/D _3986_/A _3988_/A VDD VSS sg13cmos5l_xnor2_1
X_6774_ _6775_/B _7001_/A _6913_/B _6773_/Y VDD VSS sg13cmos5l_a21oi_1
XFILLER_50_477 VDD VSS sg13cmos5l_decap_4
X_5725_ _5726_/B _5776_/A _5776_/B VDD VSS sg13cmos5l_xor2_1
X_5656_ _5657_/B _5656_/A _5656_/B VDD VSS sg13cmos5l_nor2_1
X_4607_ _4607_/Y _4607_/A VDD VSS sg13cmos5l_inv_1
X_5587_ _5589_/A _5709_/B _5588_/A VDD VSS sg13cmos5l_nor2_1
X_7326_ _7326_/Y _7326_/A _7326_/B VDD VSS sg13cmos5l_nand2_1
X_4538_ _4553_/B _4557_/A _4538_/B VDD VSS sg13cmos5l_xnor2_1
X_7257_ _7543_/B _7257_/A _7307_/B VDD VSS sg13cmos5l_nand2_1
X_4469_ _4469_/Y _4468_/B _4469_/B VDD VSS sg13cmos5l_nand2b_1
X_6208_ _6208_/Y _6212_/A _6208_/B VDD VSS sg13cmos5l_nor2_1
XFILLER_58_533 VDD VSS sg13cmos5l_fill_2
X_7188_ _7188_/Y _7187_/A _7081_/A _7187_/Y VDD VSS sg13cmos5l_a21oi_1
X_6139_ _6139_/Y _6139_/A _6139_/B VDD VSS sg13cmos5l_nand2_1
XFILLER_46_706 VDD VSS sg13cmos5l_fill_1
XFILLER_58_577 VDD VSS sg13cmos5l_decap_4
XFILLER_73_514 VDD VSS sg13cmos5l_decap_4
XFILLER_45_238 VDD VSS sg13cmos5l_fill_2
XFILLER_42_901 VDD VSS sg13cmos5l_fill_2
XFILLER_54_772 VDD VSS sg13cmos5l_fill_1
XFILLER_53_260 VDD VSS sg13cmos5l_decap_8
XFILLER_53_271 VDD VSS sg13cmos5l_fill_1
XFILLER_41_466 VDD VSS sg13cmos5l_decap_8
XFILLER_42_42 VDD VSS sg13cmos5l_fill_2
XFILLER_42_53 VDD VSS sg13cmos5l_fill_2
XFILLER_77_875 VDD VSS sg13cmos5l_fill_2
Xbank_A_sram.gen_ihp_256x32.u_sram_256x32_398 bank_A_sram.gen_ihp_256x32.u_sram_256x32_398/L_LO
+ VDD VSS sg13cmos5l_tielo
XFILLER_67_94 VDD VSS sg13cmos5l_fill_2
XFILLER_49_577 VDD VSS sg13cmos5l_fill_2
XFILLER_64_503 VDD VSS sg13cmos5l_decap_8
XFILLER_36_249 VDD VSS sg13cmos5l_decap_8
XFILLER_64_536 VDD VSS sg13cmos5l_fill_1
XFILLER_64_558 VDD VSS sg13cmos5l_decap_8
XFILLER_45_783 VDD VSS sg13cmos5l_fill_2
XFILLER_60_775 VDD VSS sg13cmos5l_fill_2
X_5510_ _5511_/B _5561_/A _5561_/B VDD VSS sg13cmos5l_xor2_1
X_6490_ _6492_/A _7289_/A _6630_/B VDD VSS sg13cmos5l_nor2_1
X_5441_ _5452_/A _5630_/A _5441_/B VDD VSS sg13cmos5l_xnor2_1
X_5372_ _5373_/B _5793_/A _5372_/B VDD VSS sg13cmos5l_xnor2_1
X_4323_ _4323_/X _4327_/B VDD VSS sg13cmos5l_buf_1
X_7111_ _7290_/A _7111_/A _7274_/A _7484_/B VDD VSS sg13cmos5l_nor3_1
X_7042_ _7043_/B _7715_/Q _7042_/B VDD VSS sg13cmos5l_xnor2_1
X_4254_ _4296_/B _4252_/Y _4229_/B _4253_/Y VDD VSS sg13cmos5l_o21ai_1
X_4185_ _4236_/B _4185_/A _4185_/B VDD VSS sg13cmos5l_xnor2_1
XFILLER_67_352 VDD VSS sg13cmos5l_fill_2
XFILLER_68_886 VDD VSS sg13cmos5l_decap_8
XFILLER_55_514 VDD VSS sg13cmos5l_fill_1
XFILLER_55_525 VDD VSS sg13cmos5l_decap_8
XFILLER_82_344 VDD VSS sg13cmos5l_decap_8
XFILLER_70_517 VDD VSS sg13cmos5l_fill_1
XFILLER_42_219 VDD VSS sg13cmos5l_decap_8
XFILLER_35_293 VDD VSS sg13cmos5l_fill_1
X_6826_ _6826_/Y _6826_/A _6826_/B VDD VSS sg13cmos5l_xnor2_1
X_6757_ _6759_/A _6757_/A _6757_/B VDD VSS sg13cmos5l_xnor2_1
XFILLER_50_274 VDD VSS sg13cmos5l_fill_1
X_3969_ _4027_/A quant_cfg[3] VDD VSS sg13cmos5l_buf_1
X_5708_ _5710_/A _5586_/A _5643_/X _5707_/Y VDD VSS sg13cmos5l_o21ai_1
XFILLER_50_296 VDD VSS sg13cmos5l_decap_8
X_6688_ _6690_/A _6688_/A _6688_/B VDD VSS sg13cmos5l_nand2_1
X_5639_ _5649_/A _5639_/A _5639_/B VDD VSS sg13cmos5l_xor2_1
X_7309_ _7310_/B _7304_/B _7305_/Y _7308_/Y VDD VSS sg13cmos5l_a21oi_1
XFILLER_59_831 VDD VSS sg13cmos5l_fill_2
XFILLER_73_333 VDD VSS sg13cmos5l_fill_2
XFILLER_37_53 VDD VSS sg13cmos5l_decap_8
XFILLER_46_558 VDD VSS sg13cmos5l_decap_8
XFILLER_61_506 VDD VSS sg13cmos5l_fill_1
XFILLER_42_731 VDD VSS sg13cmos5l_fill_2
XFILLER_42_742 VDD VSS sg13cmos5l_decap_8
XFILLER_53_30 VDD VSS sg13cmos5l_decap_8
XFILLER_41_252 VDD VSS sg13cmos5l_decap_4
XFILLER_69_606 VDD VSS sg13cmos5l_decap_8
XFILLER_68_149 VDD VSS sg13cmos5l_fill_1
XFILLER_49_374 VDD VSS sg13cmos5l_decap_8
XFILLER_49_352 VDD VSS sg13cmos5l_fill_2
XFILLER_65_823 VDD VSS sg13cmos5l_decap_8
XFILLER_49_385 VDD VSS sg13cmos5l_fill_1
XFILLER_64_333 VDD VSS sg13cmos5l_fill_2
X_5990_ _5991_/B _5990_/A _5946_/A VDD VSS sg13cmos5l_nor2b_1
X_4941_ _4942_/B _5063_/A _5199_/A _5000_/A _5200_/A VDD VSS sg13cmos5l_a22oi_1
X_7660_ _7660_/Q clkload6/A _7660_/D fanout387/X VDD VSS sg13cmos5l_dfrbpq_1
X_4872_ _4872_/X _4872_/A VDD VSS sg13cmos5l_buf_1
X_6611_ _6613_/A _6671_/A _6611_/B _6611_/C VDD VSS sg13cmos5l_nand3_1
X_7591_ _7592_/C _7591_/A _7591_/B VDD VSS sg13cmos5l_xor2_1
X_6542_ _6549_/A _6542_/A _6542_/B VDD VSS sg13cmos5l_nor2_1
X_6473_ _6841_/B _6473_/A _6473_/B VDD VSS sg13cmos5l_nand2_2
X_5424_ _5426_/A _5411_/A _5424_/B VDD VSS sg13cmos5l_nand2b_1
X_5355_ _5418_/B _5355_/A _5417_/A VDD VSS sg13cmos5l_xor2_1
X_5286_ _5288_/A _5216_/B _5286_/B VDD VSS sg13cmos5l_nand2b_1
X_4306_ _4360_/B _4268_/B _4268_/A _4305_/X VDD VSS sg13cmos5l_a21oi_1
XFILLER_114_25 VDD VSS sg13cmos5l_decap_4
X_4237_ _4243_/A _4237_/A _4248_/A VDD VSS sg13cmos5l_xnor2_1
X_7025_ _7025_/Y _7181_/A _7237_/B _7024_/X VDD VSS sg13cmos5l_o21ai_1
XFILLER_56_801 VDD VSS sg13cmos5l_decap_8
X_4168_ _4178_/A _4168_/A _4168_/B VDD VSS sg13cmos5l_xnor2_1
XFILLER_82_152 VDD VSS sg13cmos5l_fill_1
X_4099_ _4106_/A _4099_/A _4109_/A VDD VSS sg13cmos5l_xnor2_1
XFILLER_43_506 VDD VSS sg13cmos5l_fill_1
XFILLER_43_517 VDD VSS sg13cmos5l_decap_4
XFILLER_56_889 VDD VSS sg13cmos5l_fill_1
XFILLER_70_314 VDD VSS sg13cmos5l_fill_2
XFILLER_36_580 VDD VSS sg13cmos5l_decap_8
X_6809_ _6809_/X _6909_/B VDD VSS sg13cmos5l_buf_1
XFILLER_23_22 VDD VSS sg13cmos5l_decap_8
XFILLER_79_926 VDD VSS sg13cmos5l_decap_8
XFILLER_78_469 VDD VSS sg13cmos5l_decap_8
XFILLER_48_74 VDD VSS sg13cmos5l_fill_2
XFILLER_74_675 VDD VSS sg13cmos5l_decap_8
XFILLER_62_804 VDD VSS sg13cmos5l_decap_4
XFILLER_73_163 VDD VSS sg13cmos5l_decap_8
XFILLER_64_40 VDD VSS sg13cmos5l_fill_1
XFILLER_64_84 VDD VSS sg13cmos5l_fill_2
XFILLER_80_50 VDD VSS sg13cmos5l_fill_2
XFILLER_69_425 VDD VSS sg13cmos5l_decap_8
X_5140_ _5141_/B _5257_/A _5199_/A _5190_/A _5200_/A VDD VSS sg13cmos5l_a22oi_1
X_5071_ _5127_/A _5020_/B _5020_/A _5070_/Y VDD VSS sg13cmos5l_a21oi_1
X_4022_ _4025_/A _3955_/A _4262_/A _3961_/X VDD VSS sg13cmos5l_a21oi_1
XFILLER_38_834 VDD VSS sg13cmos5l_fill_1
XFILLER_37_322 VDD VSS sg13cmos5l_decap_8
XFILLER_49_160 VDD VSS sg13cmos5l_decap_8
XFILLER_38_878 VDD VSS sg13cmos5l_decap_8
XFILLER_37_366 VDD VSS sg13cmos5l_fill_1
XFILLER_53_815 VDD VSS sg13cmos5l_fill_1
X_5973_ _5973_/Y _5973_/A _5954_/A VDD VSS sg13cmos5l_nor2b_1
X_7712_ _7712_/Q clkload7/A _7712_/D fanout388/X VDD VSS sg13cmos5l_dfrbpq_1
XFILLER_52_336 VDD VSS sg13cmos5l_decap_4
X_4924_ _4924_/X _4924_/A _4924_/B VDD VSS sg13cmos5l_and2_1
XFILLER_61_870 VDD VSS sg13cmos5l_decap_8
X_7643_ _7644_/B _7643_/A _7643_/B VDD VSS sg13cmos5l_xnor2_1
X_4855_ _4855_/Y _4855_/A _4805_/A VDD VSS sg13cmos5l_nor2b_1
XFILLER_60_391 VDD VSS sg13cmos5l_fill_2
X_4786_ _4847_/B _4786_/A _4846_/A VDD VSS sg13cmos5l_xnor2_1
X_7574_ _7576_/A _7574_/A _7574_/B VDD VSS sg13cmos5l_nand2_1
X_6525_ _6534_/B _6377_/B _6541_/A VDD VSS sg13cmos5l_nand2b_1
X_6456_ _6456_/Y _6457_/A _6457_/C _6457_/B VDD VSS sg13cmos5l_a21oi_1
X_6387_ _6389_/B _6621_/A _6671_/B VDD VSS sg13cmos5l_nand2_1
X_5407_ _5409_/A _5345_/B _5407_/B VDD VSS sg13cmos5l_nand2b_1
X_5338_ _5339_/B _5572_/A _5081_/X _5505_/A _5082_/X VDD VSS sg13cmos5l_a22oi_1
X_5269_ _5269_/X _5269_/A VDD VSS sg13cmos5l_buf_1
X_7008_ _7326_/B _7235_/A _7008_/B VDD VSS sg13cmos5l_nand2_1
XFILLER_18_11 VDD VSS sg13cmos5l_decap_8
XFILLER_55_130 VDD VSS sg13cmos5l_decap_4
XFILLER_55_141 VDD VSS sg13cmos5l_decap_8
XFILLER_55_152 VDD VSS sg13cmos5l_fill_2
XFILLER_56_653 VDD VSS sg13cmos5l_fill_2
XFILLER_71_623 VDD VSS sg13cmos5l_fill_2
XFILLER_71_612 VDD VSS sg13cmos5l_fill_2
XFILLER_44_837 VDD VSS sg13cmos5l_fill_1
XFILLER_44_826 VDD VSS sg13cmos5l_decap_8
XFILLER_56_697 VDD VSS sg13cmos5l_fill_2
XFILLER_56_686 VDD VSS sg13cmos5l_decap_8
XFILLER_70_144 VDD VSS sg13cmos5l_decap_8
XFILLER_34_21 VDD VSS sg13cmos5l_decap_8
XFILLER_44_859 VDD VSS sg13cmos5l_decap_8
XFILLER_71_678 VDD VSS sg13cmos5l_decap_8
XFILLER_70_166 VDD VSS sg13cmos5l_decap_4
XFILLER_79_723 VDD VSS sg13cmos5l_decap_8
XFILLER_59_73 VDD VSS sg13cmos5l_decap_4
XFILLER_59_95 VDD VSS sg13cmos5l_decap_8
XFILLER_78_255 VDD VSS sg13cmos5l_decap_8
Xclkbuf_4_3_0_clk_i_regs clkload1/A clkbuf_0_clk_i_regs/X VDD VSS sg13cmos5l_buf_8
XFILLER_15_8 VDD VSS sg13cmos5l_decap_4
XFILLER_47_631 VDD VSS sg13cmos5l_fill_1
Xfanout290 _6918_/B _6947_/B VDD VSS sg13cmos5l_buf_1
XFILLER_46_152 VDD VSS sg13cmos5l_fill_2
XFILLER_61_177 VDD VSS sg13cmos5l_fill_1
X_4640_ _4640_/X _4640_/A VDD VSS sg13cmos5l_buf_1
X_6310_ _6787_/B _6310_/A _6310_/B VDD VSS sg13cmos5l_nand2_2
X_4571_ _4602_/A _4571_/A _4571_/B VDD VSS sg13cmos5l_xor2_1
X_7290_ _7290_/Y _7290_/A _7290_/B _7290_/C VDD VSS sg13cmos5l_nor3_1
X_6241_ _6277_/A _6241_/A _6353_/A VDD VSS sg13cmos5l_nand2_2
X_6172_ _7705_/D _6172_/A _6172_/B VDD VSS sg13cmos5l_xor2_1
X_5123_ _5123_/X _5123_/A _5123_/B VDD VSS sg13cmos5l_and2_1
XFILLER_58_929 VDD VSS sg13cmos5l_decap_4
XFILLER_38_620 VDD VSS sg13cmos5l_decap_4
X_5054_ _5054_/X _5054_/A _5054_/B VDD VSS sg13cmos5l_and2_1
X_4005_ _4005_/Y _4005_/A _4005_/B VDD VSS sg13cmos5l_nor2_2
XFILLER_37_130 VDD VSS sg13cmos5l_decap_8
XFILLER_111_15 VDD VSS sg13cmos5l_decap_8
XFILLER_80_420 VDD VSS sg13cmos5l_decap_8
XFILLER_41_807 VDD VSS sg13cmos5l_decap_8
X_5956_ _5999_/B _5956_/A _5975_/A VDD VSS sg13cmos5l_xnor2_1
XFILLER_53_678 VDD VSS sg13cmos5l_decap_4
XFILLER_80_497 VDD VSS sg13cmos5l_decap_8
X_5887_ _5889_/C _5933_/B _5933_/A VDD VSS sg13cmos5l_xor2_1
X_4907_ _4968_/A _4969_/B _4969_/A VDD VSS sg13cmos5l_xor2_1
X_7626_ _7627_/B _7626_/A _7626_/B _7626_/C VDD VSS sg13cmos5l_nand3_1
X_4838_ _4839_/B _4776_/A _4838_/B VDD VSS sg13cmos5l_nand2b_1
X_4769_ _4818_/A _4585_/X _5063_/A _4768_/Y VDD VSS sg13cmos5l_a21o_1
X_7557_ _7558_/A _7557_/A _7557_/B VDD VSS sg13cmos5l_nor2_1
Xrebuffer835 _7646_/A1 _7123_/A VDD VSS sg13cmos5l_buf_1
Xrebuffer846 _6835_/B _6488_/A VDD VSS sg13cmos5l_buf_1
X_6508_ _6518_/C _6508_/A _6508_/B VDD VSS sg13cmos5l_nand2_1
X_7488_ _7489_/B _7488_/A _7488_/B VDD VSS sg13cmos5l_nand2_2
X_6439_ _6548_/D _6541_/A VDD VSS sg13cmos5l_inv_1
XFILLER_76_704 VDD VSS sg13cmos5l_fill_1
XFILLER_49_929 VDD VSS sg13cmos5l_decap_4
XFILLER_45_31 VDD VSS sg13cmos5l_decap_4
XFILLER_43_111 VDD VSS sg13cmos5l_decap_4
XFILLER_71_475 VDD VSS sg13cmos5l_fill_2
XFILLER_45_75 VDD VSS sg13cmos5l_fill_2
XANTENNA_7 _7695_/D VDD VSS sg13cmos5l_antennanp
XFILLER_79_531 VDD VSS sg13cmos5l_fill_1
XFILLER_79_597 VDD VSS sg13cmos5l_decap_4
XFILLER_82_707 VDD VSS sg13cmos5l_fill_1
XFILLER_66_247 VDD VSS sg13cmos5l_decap_8
XFILLER_35_612 VDD VSS sg13cmos5l_fill_2
XFILLER_47_483 VDD VSS sg13cmos5l_fill_1
XFILLER_63_921 VDD VSS sg13cmos5l_decap_8
XFILLER_63_932 VDD VSS sg13cmos5l_fill_2
XFILLER_35_656 VDD VSS sg13cmos5l_decap_4
XFILLER_35_645 VDD VSS sg13cmos5l_decap_8
X_5810_ _5810_/Y _5810_/A _5810_/B VDD VSS sg13cmos5l_nand2_1
X_6790_ _6968_/A _6790_/A _6790_/B VDD VSS sg13cmos5l_xnor2_1
X_5741_ _5741_/Y _5742_/B _5742_/A VDD VSS sg13cmos5l_nand2_1
XFILLER_50_648 VDD VSS sg13cmos5l_fill_1
XFILLER_50_659 VDD VSS sg13cmos5l_decap_8
X_5672_ _5674_/C _5733_/B _5733_/A VDD VSS sg13cmos5l_xor2_1
X_7411_ _7414_/B _7411_/A VDD VSS sg13cmos5l_inv_1
X_4623_ _4623_/X _4623_/A _4623_/B VDD VSS sg13cmos5l_and2_1
X_7342_ _7348_/A _7342_/A _7342_/B _7524_/A VDD VSS sg13cmos5l_nand3_1
X_4554_ _4614_/A _4542_/A _4552_/Y _4553_/Y VDD VSS sg13cmos5l_o21ai_1
X_7273_ _7366_/A _7292_/A VDD VSS sg13cmos5l_buf_2
X_6224_ _6224_/Y _6219_/A _6201_/Y _6223_/Y VDD VSS sg13cmos5l_o21ai_1
X_4485_ _4550_/A _4485_/A VDD VSS sg13cmos5l_buf_1
X_6155_ _6155_/X _6155_/A _6155_/B VDD VSS sg13cmos5l_and2_1
X_5106_ _5107_/B _5104_/Y _5106_/B VDD VSS sg13cmos5l_nand2b_1
X_6086_ _6107_/B _6117_/B _6117_/A VDD VSS sg13cmos5l_xnor2_1
XFILLER_66_19 VDD VSS sg13cmos5l_decap_8
X_5037_ _5037_/Y _4972_/A _4974_/X _4972_/B VDD VSS sg13cmos5l_o21ai_1
XFILLER_57_269 VDD VSS sg13cmos5l_fill_1
XFILLER_66_770 VDD VSS sg13cmos5l_decap_8
XFILLER_81_751 VDD VSS sg13cmos5l_decap_8
XFILLER_41_604 VDD VSS sg13cmos5l_decap_8
XFILLER_53_464 VDD VSS sg13cmos5l_fill_2
XFILLER_80_283 VDD VSS sg13cmos5l_decap_8
X_6988_ _6989_/B _6988_/A _7714_/Q _6988_/C VDD VSS sg13cmos5l_nand3_1
XFILLER_41_648 VDD VSS sg13cmos5l_fill_2
XFILLER_40_125 VDD VSS sg13cmos5l_fill_2
X_5939_ _5939_/Y _5939_/A _5915_/A VDD VSS sg13cmos5l_nor2b_1
XFILLER_40_169 VDD VSS sg13cmos5l_fill_2
Xrebuffer621 _7517_/B rebuffer690/X VDD VSS sg13cmos5l_buf_1
Xrebuffer632 rebuffer632/X rebuffer633/X VDD VSS sg13cmos5l_buf_1
X_7609_ _7610_/A _7609_/A _7609_/B VDD VSS sg13cmos5l_nand2_2
XFILLER_110_4 VDD VSS sg13cmos5l_decap_8
Xrebuffer665 rebuffer665/X rebuffer666/X VDD VSS sg13cmos5l_buf_1
Xrebuffer676 rebuffer676/X rebuffer677/X VDD VSS sg13cmos5l_buf_1
Xrebuffer654 rebuffer654/X rebuffer655/X VDD VSS sg13cmos5l_buf_1
Xrebuffer643 _7253_/A1 _7050_/Y VDD VSS sg13cmos5l_buf_1
Xrebuffer687 rebuffer687/X rebuffer696/X VDD VSS sg13cmos5l_buf_1
Xrebuffer698 _6878_/A1 _6505_/A VDD VSS sg13cmos5l_buf_1
Xinput100 _7719_/D quant_cfg[28] VDD VSS sg13cmos5l_buf_1
XFILLER_76_501 VDD VSS sg13cmos5l_fill_2
Xbank_A_sram.gen_ihp_256x32.u_sram_256x32_558 bank_A_sram.gen_ihp_256x32.u_sram_256x32_558/L_HI
+ VDD VSS sg13cmos5l_tiehi
Xbank_A_sram.gen_ihp_256x32.u_sram_256x32_569 bank_A_sram.gen_ihp_256x32.u_sram_256x32_569/L_HI
+ VDD VSS sg13cmos5l_tiehi
XFILLER_49_759 VDD VSS sg13cmos5l_fill_1
XFILLER_76_567 VDD VSS sg13cmos5l_decap_4
XFILLER_64_707 VDD VSS sg13cmos5l_decap_8
XFILLER_56_63 VDD VSS sg13cmos5l_decap_8
XFILLER_57_781 VDD VSS sg13cmos5l_decap_4
XFILLER_72_740 VDD VSS sg13cmos5l_decap_4
XFILLER_44_431 VDD VSS sg13cmos5l_fill_2
Xbank_B_sram.gen_ihp_256x32.u_sram_256x32_540 bank_B_sram.gen_ihp_256x32.u_sram_256x32_540/L_LO
+ VDD VSS sg13cmos5l_tielo
XFILLER_60_902 VDD VSS sg13cmos5l_fill_1
XFILLER_71_261 VDD VSS sg13cmos5l_fill_2
Xbank_B_sram.gen_ihp_256x32.u_sram_256x32_584 bank_B_sram.gen_ihp_256x32.u_sram_256x32/A_BM[2]
+ VDD VSS sg13cmos5l_tiehi
Xbank_B_sram.gen_ihp_256x32.u_sram_256x32_595 bank_B_sram.gen_ihp_256x32.u_sram_256x32_595/L_HI
+ VDD VSS sg13cmos5l_tiehi
XFILLER_40_692 VDD VSS sg13cmos5l_fill_1
X_4270_ _4283_/A _4225_/B _4225_/A _4269_/Y VDD VSS sg13cmos5l_a21oi_1
XFILLER_79_394 VDD VSS sg13cmos5l_decap_4
XFILLER_67_556 VDD VSS sg13cmos5l_fill_1
XFILLER_67_578 VDD VSS sg13cmos5l_fill_1
XFILLER_36_921 VDD VSS sg13cmos5l_decap_8
XFILLER_55_718 VDD VSS sg13cmos5l_decap_8
XFILLER_36_932 VDD VSS sg13cmos5l_fill_2
X_6911_ _6911_/Y _6764_/Y _6960_/B VDD VSS sg13cmos5l_nand2b_1
XFILLER_47_280 VDD VSS sg13cmos5l_decap_8
XFILLER_54_239 VDD VSS sg13cmos5l_decap_4
X_6842_ _6843_/A _6842_/A _6842_/B VDD VSS sg13cmos5l_xor2_1
XFILLER_50_401 VDD VSS sg13cmos5l_decap_8
XFILLER_62_283 VDD VSS sg13cmos5l_fill_1
X_3985_ _3988_/A _3987_/B _3987_/A VDD VSS sg13cmos5l_xnor2_1
X_6773_ _6773_/Y _6943_/A _7028_/A VDD VSS sg13cmos5l_nor2_1
X_5724_ _5776_/B _5722_/Y _5652_/A _5723_/Y VDD VSS sg13cmos5l_a21oi_1
X_5655_ _5656_/B _5655_/A _5594_/A VDD VSS sg13cmos5l_nor2b_1
X_4606_ _4726_/B _4606_/A _4606_/B _4607_/A VDD VSS sg13cmos5l_nor3_1
X_7325_ _7332_/A _7550_/B _7551_/A _7551_/B VDD VSS sg13cmos5l_nand3_1
X_5586_ _5588_/A _5586_/A _5586_/B VDD VSS sg13cmos5l_xnor2_1
X_4537_ _4538_/B _4537_/A _4558_/B VDD VSS sg13cmos5l_xor2_1
X_7256_ _7542_/A _7259_/A _7307_/B VDD VSS sg13cmos5l_nand2b_1
X_4468_ _4545_/A _4473_/B _4468_/B VDD VSS sg13cmos5l_nand2_1
XFILLER_77_309 VDD VSS sg13cmos5l_decap_8
X_6207_ _6207_/Y _6207_/A VDD VSS sg13cmos5l_inv_1
X_7187_ _7187_/Y _7187_/A _7187_/B VDD VSS sg13cmos5l_nor2_1
X_6138_ _6163_/A _6138_/A _6138_/B VDD VSS sg13cmos5l_xnor2_1
X_4399_ _4399_/Y _4399_/A VDD VSS sg13cmos5l_inv_1
XFILLER_45_217 VDD VSS sg13cmos5l_fill_2
XFILLER_46_718 VDD VSS sg13cmos5l_decap_8
X_6069_ _6097_/A _6035_/B _6067_/Y _6068_/Y VDD VSS sg13cmos5l_a21oi_1
XFILLER_73_548 VDD VSS sg13cmos5l_decap_8
XFILLER_38_291 VDD VSS sg13cmos5l_decap_8
XFILLER_54_740 VDD VSS sg13cmos5l_decap_8
XFILLER_54_784 VDD VSS sg13cmos5l_decap_4
XFILLER_53_294 VDD VSS sg13cmos5l_fill_2
XFILLER_42_21 VDD VSS sg13cmos5l_fill_2
XFILLER_41_489 VDD VSS sg13cmos5l_decap_8
XFILLER_42_87 VDD VSS sg13cmos5l_decap_8
XFILLER_3_26 VDD VSS sg13cmos5l_fill_2
XFILLER_77_854 VDD VSS sg13cmos5l_decap_8
Xbank_A_sram.gen_ihp_256x32.u_sram_256x32_399 bank_A_sram.gen_ihp_256x32.u_sram_256x32_399/L_LO
+ VDD VSS sg13cmos5l_tielo
XFILLER_36_228 VDD VSS sg13cmos5l_decap_8
XFILLER_44_261 VDD VSS sg13cmos5l_decap_4
XFILLER_60_743 VDD VSS sg13cmos5l_decap_8
XFILLER_60_787 VDD VSS sg13cmos5l_decap_8
X_5440_ _5441_/B _5190_/X _5568_/A _5131_/X _5569_/A VDD VSS sg13cmos5l_a22oi_1
X_5371_ _5372_/B _5557_/B1 _5118_/X _5493_/B1 _5119_/X VDD VSS sg13cmos5l_a22oi_1
XFILLER_59_2 VDD VSS sg13cmos5l_fill_1
X_4322_ _4333_/A _4761_/A _4322_/B VDD VSS sg13cmos5l_xnor2_1
X_7110_ _7110_/Y _7107_/Y _7153_/A _7109_/Y VDD VSS sg13cmos5l_a21oi_2
X_4253_ _4253_/Y _4228_/A _4253_/B VDD VSS sg13cmos5l_nand2b_1
X_7041_ _7042_/B _7096_/A _7096_/C VDD VSS sg13cmos5l_nand2_1
XFILLER_68_821 VDD VSS sg13cmos5l_decap_8
XFILLER_79_191 VDD VSS sg13cmos5l_decap_8
X_4184_ _4185_/B _4230_/A _4230_/B VDD VSS sg13cmos5l_xor2_1
XFILLER_68_865 VDD VSS sg13cmos5l_decap_8
XFILLER_67_375 VDD VSS sg13cmos5l_decap_8
XFILLER_82_312 VDD VSS sg13cmos5l_decap_4
XFILLER_51_743 VDD VSS sg13cmos5l_fill_1
X_6825_ _6825_/Y _6822_/X _6813_/S _6824_/X VDD VSS sg13cmos5l_a21oi_1
X_3968_ _3986_/A _3968_/A _3970_/B VDD VSS sg13cmos5l_nor2_1
X_6756_ _6915_/B _6756_/A _6756_/B VDD VSS sg13cmos5l_xnor2_1
X_5707_ _5707_/Y _5586_/A _3948_/B _5706_/Y VDD VSS sg13cmos5l_o21ai_1
X_6687_ _6716_/B _6687_/A _6687_/B VDD VSS sg13cmos5l_nand2_2
X_5638_ _5639_/B _5690_/A _5690_/B VDD VSS sg13cmos5l_xor2_1
X_5569_ _5569_/X _5569_/A VDD VSS sg13cmos5l_buf_1
X_7308_ _7308_/Y _7308_/A _7555_/B VDD VSS sg13cmos5l_nand2_1
XFILLER_78_618 VDD VSS sg13cmos5l_decap_8
XFILLER_78_607 VDD VSS sg13cmos5l_fill_2
X_7239_ _7239_/Y _7179_/X _7038_/A _7238_/Y VDD VSS sg13cmos5l_o21ai_1
XFILLER_77_139 VDD VSS sg13cmos5l_decap_8
XFILLER_37_32 VDD VSS sg13cmos5l_decap_8
XFILLER_74_846 VDD VSS sg13cmos5l_fill_1
XFILLER_46_537 VDD VSS sg13cmos5l_fill_1
Xclkbuf_4_8_0_clk_i_regs _7691_/CLK clkbuf_0_clk_i_regs/X VDD VSS sg13cmos5l_buf_8
XFILLER_82_890 VDD VSS sg13cmos5l_fill_2
XFILLER_42_710 VDD VSS sg13cmos5l_decap_4
XFILLER_53_20 VDD VSS sg13cmos5l_decap_4
XFILLER_61_529 VDD VSS sg13cmos5l_fill_1
XFILLER_78_83 VDD VSS sg13cmos5l_fill_2
XFILLER_65_802 VDD VSS sg13cmos5l_decap_4
XFILLER_76_194 VDD VSS sg13cmos5l_decap_4
XFILLER_80_816 VDD VSS sg13cmos5l_fill_1
XFILLER_65_868 VDD VSS sg13cmos5l_decap_4
X_4940_ _4994_/A _4895_/B _4895_/A _4939_/Y VDD VSS sg13cmos5l_a21oi_1
XFILLER_60_540 VDD VSS sg13cmos5l_fill_1
X_4871_ _5133_/A _4871_/A VDD VSS sg13cmos5l_buf_1
X_6610_ _6618_/A _6610_/A _6610_/B VDD VSS sg13cmos5l_nand2_2
X_7590_ _7591_/B _7590_/A _7590_/B VDD VSS sg13cmos5l_nand2_1
XFILLER_60_584 VDD VSS sg13cmos5l_fill_2
X_6541_ _6549_/B _6541_/A _6541_/B VDD VSS sg13cmos5l_nand2_1
X_6472_ _6473_/B _6470_/B _7679_/Q VDD VSS sg13cmos5l_nand2b_1
X_5423_ _7688_/D _5485_/B _5423_/B VDD VSS sg13cmos5l_xor2_1
X_5354_ _5417_/A _5363_/B _5363_/A VDD VSS sg13cmos5l_xnor2_1
X_4305_ _4305_/X _4305_/A _4305_/B VDD VSS sg13cmos5l_and2_1
X_5285_ _5351_/B _5346_/A _5285_/B VDD VSS sg13cmos5l_xnor2_1
X_4236_ _4237_/A _4236_/A _4236_/B VDD VSS sg13cmos5l_nor2_1
XFILLER_68_640 VDD VSS sg13cmos5l_decap_8
X_7024_ _7024_/X _7020_/Y _7023_/Y _7076_/B VDD VSS sg13cmos5l_a21o_1
X_4167_ _4168_/B _4262_/A _3998_/A _4205_/A _4641_/A VDD VSS sg13cmos5l_a22oi_1
XFILLER_56_824 VDD VSS sg13cmos5l_decap_4
XFILLER_55_334 VDD VSS sg13cmos5l_decap_8
XFILLER_56_857 VDD VSS sg13cmos5l_fill_1
X_4098_ _4109_/A _4138_/B _4138_/A VDD VSS sg13cmos5l_xor2_1
XFILLER_71_805 VDD VSS sg13cmos5l_decap_8
XFILLER_55_367 VDD VSS sg13cmos5l_fill_2
XFILLER_43_529 VDD VSS sg13cmos5l_fill_1
XFILLER_64_890 VDD VSS sg13cmos5l_decap_8
XFILLER_90_18 VDD VSS sg13cmos5l_decap_8
X_6808_ _6808_/Y _6801_/Y _6356_/A _6807_/Y VDD VSS sg13cmos5l_a21oi_1
X_6739_ _6739_/Y _6739_/A VDD VSS sg13cmos5l_inv_1
XFILLER_78_426 VDD VSS sg13cmos5l_fill_1
XFILLER_78_448 VDD VSS sg13cmos5l_decap_8
XFILLER_0_16 VDD VSS sg13cmos5l_decap_8
XFILLER_0_27 VDD VSS sg13cmos5l_fill_2
XFILLER_73_186 VDD VSS sg13cmos5l_decap_4
XFILLER_46_378 VDD VSS sg13cmos5l_fill_2
XFILLER_36_4 VDD VSS sg13cmos5l_decap_8
X_5070_ _5070_/Y _5070_/A _5070_/B VDD VSS sg13cmos5l_nor2_1
XFILLER_69_448 VDD VSS sg13cmos5l_fill_1
X_4021_ _4262_/A _4021_/A VDD VSS sg13cmos5l_buf_4
XFILLER_38_813 VDD VSS sg13cmos5l_fill_1
XFILLER_37_301 VDD VSS sg13cmos5l_decap_8
XFILLER_65_632 VDD VSS sg13cmos5l_decap_8
X_5972_ _7698_/D _5972_/A _6016_/A VDD VSS sg13cmos5l_nor2b_2
XFILLER_52_326 VDD VSS sg13cmos5l_fill_2
XFILLER_53_838 VDD VSS sg13cmos5l_fill_1
XFILLER_64_175 VDD VSS sg13cmos5l_decap_4
X_7711_ _7711_/Q clkload7/A _7711_/D fanout388/X VDD VSS sg13cmos5l_dfrbpq_1
X_4923_ _4926_/A _4985_/S _4923_/B VDD VSS sg13cmos5l_xnor2_1
XFILLER_64_197 VDD VSS sg13cmos5l_fill_1
XFILLER_100_28 VDD VSS sg13cmos5l_fill_1
X_7642_ _7643_/B _7642_/A _7642_/B VDD VSS sg13cmos5l_nand2_1
X_4854_ _4984_/A _4854_/A VDD VSS sg13cmos5l_buf_1
XFILLER_61_893 VDD VSS sg13cmos5l_fill_1
X_7573_ _7580_/A _7573_/A _7573_/B _7621_/D VDD VSS sg13cmos5l_and3_1
X_4785_ _4846_/A _4785_/A _4785_/B VDD VSS sg13cmos5l_nand2_1
X_6524_ _6531_/A _6524_/A _6524_/B VDD VSS sg13cmos5l_nand2_2
XFILLER_109_15 VDD VSS sg13cmos5l_decap_8
X_6455_ _6457_/B _6291_/B _6465_/A VDD VSS sg13cmos5l_nand2b_1
X_6386_ _6671_/B _6979_/B _6516_/A _6982_/A _6533_/C VDD VSS sg13cmos5l_nor4_1
X_5406_ _5425_/B _5471_/B _5406_/B VDD VSS sg13cmos5l_xnor2_1
X_5337_ _5389_/A _5142_/X _5633_/A _5336_/Y VDD VSS sg13cmos5l_a21o_1
X_5268_ _5456_/A _5331_/A VDD VSS sg13cmos5l_buf_1
XFILLER_75_407 VDD VSS sg13cmos5l_decap_8
X_4219_ _4220_/B _4276_/A _4327_/B _4219_/C VDD VSS sg13cmos5l_nor3_1
X_7007_ _7235_/A _7030_/B _7161_/A _7006_/Y VDD VSS sg13cmos5l_o21ai_1
X_5199_ _5199_/X _5199_/A VDD VSS sg13cmos5l_buf_1
XFILLER_70_112 VDD VSS sg13cmos5l_decap_4
XFILLER_55_197 VDD VSS sg13cmos5l_decap_4
XFILLER_70_178 VDD VSS sg13cmos5l_decap_4
XFILLER_50_76 VDD VSS sg13cmos5l_fill_1
XFILLER_78_234 VDD VSS sg13cmos5l_decap_8
XFILLER_66_407 VDD VSS sg13cmos5l_fill_2
XFILLER_38_109 VDD VSS sg13cmos5l_decap_8
Xfanout280 _7076_/B _6809_/X VDD VSS sg13cmos5l_buf_1
Xfanout291 _6979_/B _6908_/B VDD VSS sg13cmos5l_buf_4
XFILLER_75_73 VDD VSS sg13cmos5l_decap_8
XFILLER_75_51 VDD VSS sg13cmos5l_decap_8
XFILLER_47_643 VDD VSS sg13cmos5l_decap_8
XFILLER_74_484 VDD VSS sg13cmos5l_fill_2
X_4570_ _4571_/B _4616_/B _4616_/A VDD VSS sg13cmos5l_xor2_1
X_6240_ _6353_/A _7711_/Q VDD VSS sg13cmos5l_buf_8
X_6171_ _6172_/B _6157_/B _6157_/A _6170_/X VDD VSS sg13cmos5l_a21o_1
XFILLER_69_234 VDD VSS sg13cmos5l_fill_1
XFILLER_69_223 VDD VSS sg13cmos5l_fill_1
X_5122_ _5125_/A _5177_/S _5122_/B VDD VSS sg13cmos5l_xnor2_1
XFILLER_57_407 VDD VSS sg13cmos5l_fill_1
X_5053_ _5056_/A _5115_/S _5053_/B VDD VSS sg13cmos5l_xnor2_1
X_4004_ _4005_/A _4525_/A _4004_/B _4172_/B VDD VSS sg13cmos5l_nor3_2
XFILLER_81_933 VDD VSS sg13cmos5l_fill_1
XFILLER_37_186 VDD VSS sg13cmos5l_decap_8
XFILLER_53_635 VDD VSS sg13cmos5l_fill_2
XFILLER_80_476 VDD VSS sg13cmos5l_decap_8
X_5955_ _5975_/A _5955_/A _5955_/B VDD VSS sg13cmos5l_xnor2_1
XFILLER_52_167 VDD VSS sg13cmos5l_decap_8
X_5886_ _5933_/A _6042_/A _5885_/Y _5838_/B VDD VSS sg13cmos5l_o21ai_1
X_4906_ _4969_/A _4840_/B _4840_/A _4905_/Y VDD VSS sg13cmos5l_a21o_1
X_4837_ _4839_/A _4777_/B _4837_/B VDD VSS sg13cmos5l_nand2b_1
X_7625_ _7626_/C _7625_/A _7625_/B VDD VSS sg13cmos5l_nor2_1
X_7556_ _7560_/B _7556_/A _7556_/B VDD VSS sg13cmos5l_xor2_1
X_4768_ _4768_/Y _4768_/A _4768_/B VDD VSS sg13cmos5l_nor2_1
Xrebuffer847 _6873_/B _6539_/A VDD VSS sg13cmos5l_buf_1
Xrebuffer836 _6754_/B _6635_/A VDD VSS sg13cmos5l_buf_1
X_4699_ _5063_/A _4699_/A VDD VSS sg13cmos5l_buf_1
X_7487_ _7488_/B _7477_/B _7603_/A VDD VSS sg13cmos5l_nand2b_1
X_6507_ _6518_/B _6507_/A _6548_/D VDD VSS sg13cmos5l_nor2_1
X_6438_ _6445_/A _6438_/A _6438_/B VDD VSS sg13cmos5l_nand2_2
X_6369_ _6379_/A _6369_/A VDD VSS sg13cmos5l_buf_2
XFILLER_76_749 VDD VSS sg13cmos5l_decap_8
XFILLER_72_933 VDD VSS sg13cmos5l_fill_1
XFILLER_40_896 VDD VSS sg13cmos5l_decap_8
XFILLER_6_15 VDD VSS sg13cmos5l_decap_8
XANTENNA_8 _7698_/D VDD VSS sg13cmos5l_antennanp
XFILLER_79_587 VDD VSS sg13cmos5l_fill_2
XFILLER_39_429 VDD VSS sg13cmos5l_fill_2
XFILLER_47_473 VDD VSS sg13cmos5l_fill_2
XFILLER_74_281 VDD VSS sg13cmos5l_decap_8
XFILLER_74_270 VDD VSS sg13cmos5l_fill_1
XFILLER_35_679 VDD VSS sg13cmos5l_decap_4
XFILLER_50_616 VDD VSS sg13cmos5l_fill_1
XFILLER_50_605 VDD VSS sg13cmos5l_decap_8
XFILLER_62_454 VDD VSS sg13cmos5l_fill_2
X_5740_ _5774_/A _5693_/B _5693_/A _5739_/Y VDD VSS sg13cmos5l_a21oi_1
X_5671_ _5733_/A _5781_/A _5670_/Y _5609_/B VDD VSS sg13cmos5l_o21ai_1
X_7410_ _7411_/A _7410_/A _7424_/A VDD VSS sg13cmos5l_nand2_1
X_4622_ _4625_/A _4674_/S _4622_/B VDD VSS sg13cmos5l_xnor2_1
X_7341_ _7524_/A _7335_/A _7352_/A VDD VSS sg13cmos5l_nand2b_1
X_4553_ _4553_/Y _4553_/A _4553_/B VDD VSS sg13cmos5l_nand2_1
X_7272_ _7304_/A _7272_/A _7530_/A VDD VSS sg13cmos5l_nor2b_2
X_4484_ _4485_/A _4463_/B _4463_/A _4483_/Y VDD VSS sg13cmos5l_a21o_1
X_6223_ _6223_/Y _6223_/A _6223_/B VDD VSS sg13cmos5l_nand2_1
X_6154_ _6157_/A _6170_/B _6170_/A VDD VSS sg13cmos5l_xor2_1
X_5105_ _5106_/B _5105_/A _5105_/B VDD VSS sg13cmos5l_nand2_2
X_6085_ _6117_/A _6085_/A _6085_/B VDD VSS sg13cmos5l_xnor2_1
X_5036_ _5105_/B _5036_/A _5103_/A VDD VSS sg13cmos5l_xor2_1
XFILLER_57_248 VDD VSS sg13cmos5l_decap_8
XFILLER_54_911 VDD VSS sg13cmos5l_fill_1
XFILLER_38_484 VDD VSS sg13cmos5l_fill_2
XFILLER_54_933 VDD VSS sg13cmos5l_fill_1
X_6987_ _6989_/A _7635_/A _7635_/B VDD VSS sg13cmos5l_nand2_2
XFILLER_53_443 VDD VSS sg13cmos5l_fill_2
XFILLER_80_262 VDD VSS sg13cmos5l_decap_8
XFILLER_40_104 VDD VSS sg13cmos5l_decap_8
XFILLER_15_24 VDD VSS sg13cmos5l_decap_4
X_5938_ _6010_/B _5938_/A _5925_/A VDD VSS sg13cmos5l_nor2b_1
X_5869_ _5870_/B _6136_/B _5869_/A2 _6114_/B _5869_/B2 VDD VSS sg13cmos5l_a22oi_1
Xrebuffer633 rebuffer633/X rebuffer634/X VDD VSS sg13cmos5l_buf_1
X_7608_ _7609_/B _7608_/A _7608_/B VDD VSS sg13cmos5l_nand2_2
Xrebuffer622 _7651_/A _7151_/A VDD VSS sg13cmos5l_buf_1
Xrebuffer666 rebuffer666/X rebuffer667/X VDD VSS sg13cmos5l_buf_1
X_7539_ _7539_/Y _7539_/A1 _7536_/A _7217_/B VDD VSS sg13cmos5l_a21oi_1
Xrebuffer655 rebuffer655/X rebuffer656/X VDD VSS sg13cmos5l_buf_1
Xrebuffer644 _6799_/A _6286_/B VDD VSS sg13cmos5l_buf_1
Xrebuffer677 rebuffer677/X rebuffer678/X VDD VSS sg13cmos5l_buf_1
Xrebuffer699 _6268_/A _6251_/Y VDD VSS sg13cmos5l_buf_2
Xrebuffer688 _7425_/A2 _7058_/Y VDD VSS sg13cmos5l_buf_1
XFILLER_103_4 VDD VSS sg13cmos5l_decap_8
Xinput101 _7720_/D quant_cfg[29] VDD VSS sg13cmos5l_buf_1
Xbank_A_sram.gen_ihp_256x32.u_sram_256x32_548 bank_A_sram.gen_ihp_256x32.u_sram_256x32/A_BM[0]
+ VDD VSS sg13cmos5l_tiehi
Xbank_A_sram.gen_ihp_256x32.u_sram_256x32_559 bank_A_sram.gen_ihp_256x32.u_sram_256x32_559/L_HI
+ VDD VSS sg13cmos5l_tiehi
XFILLER_48_237 VDD VSS sg13cmos5l_fill_2
XFILLER_56_31 VDD VSS sg13cmos5l_decap_8
XFILLER_45_933 VDD VSS sg13cmos5l_fill_1
XFILLER_56_292 VDD VSS sg13cmos5l_fill_1
Xbank_B_sram.gen_ihp_256x32.u_sram_256x32_541 bank_B_sram.gen_ihp_256x32.u_sram_256x32_541/L_LO
+ VDD VSS sg13cmos5l_tielo
Xbank_B_sram.gen_ihp_256x32.u_sram_256x32_530 bank_B_sram.gen_ihp_256x32.u_sram_256x32_530/L_LO
+ VDD VSS sg13cmos5l_tielo
Xbank_B_sram.gen_ihp_256x32.u_sram_256x32_585 bank_B_sram.gen_ihp_256x32.u_sram_256x32/A_BM[3]
+ VDD VSS sg13cmos5l_tiehi
XFILLER_44_476 VDD VSS sg13cmos5l_decap_8
Xbank_B_sram.gen_ihp_256x32.u_sram_256x32_596 bank_B_sram.gen_ihp_256x32.u_sram_256x32_596/L_HI
+ VDD VSS sg13cmos5l_tiehi
XFILLER_79_373 VDD VSS sg13cmos5l_decap_8
XFILLER_67_524 VDD VSS sg13cmos5l_fill_1
XFILLER_39_259 VDD VSS sg13cmos5l_decap_8
XFILLER_36_900 VDD VSS sg13cmos5l_decap_8
XFILLER_54_218 VDD VSS sg13cmos5l_decap_8
XFILLER_35_410 VDD VSS sg13cmos5l_fill_1
X_6910_ _7069_/A _6771_/Y _6766_/A _6910_/S VDD VSS sg13cmos5l_mux2_1
XFILLER_35_443 VDD VSS sg13cmos5l_decap_8
X_6841_ _6841_/X _6841_/A _6841_/B VDD VSS sg13cmos5l_xor2_1
XFILLER_51_903 VDD VSS sg13cmos5l_fill_1
X_3984_ _3987_/B _3993_/B _3993_/A VDD VSS sg13cmos5l_xnor2_1
X_6772_ _7028_/A _6770_/Y _6771_/Y _6941_/B VDD VSS sg13cmos5l_mux2_1
XFILLER_50_457 VDD VSS sg13cmos5l_fill_2
X_5723_ _5723_/Y _5723_/A _5653_/A VDD VSS sg13cmos5l_nor2b_1
X_5654_ _5656_/A _5654_/A _5593_/A VDD VSS sg13cmos5l_nor2b_1
X_4605_ _4607_/A _4614_/A _4614_/B VDD VSS sg13cmos5l_xnor2_1
X_7324_ _7551_/B _7324_/A _7324_/B VDD VSS sg13cmos5l_nand2_1
X_5585_ _5586_/B _5755_/A _5644_/A2 _5712_/A _5644_/B2 VDD VSS sg13cmos5l_a22oi_1
X_4536_ _4558_/B _4599_/B _4599_/A VDD VSS sg13cmos5l_xor2_1
X_7255_ _7259_/A _6416_/A _7252_/Y _7254_/X VDD VSS sg13cmos5l_o21ai_1
X_4467_ _4468_/B _4467_/A _4467_/B VDD VSS sg13cmos5l_and2_1
XFILLER_77_19 VDD VSS sg13cmos5l_fill_1
X_6206_ _6206_/Y _6209_/A1 _6204_/Y _6205_/Y VDD VSS sg13cmos5l_a21oi_1
X_4398_ _4461_/B _4457_/B _4457_/A VDD VSS sg13cmos5l_xor2_1
X_7186_ _7186_/Y _7186_/A _7205_/A VDD VSS sg13cmos5l_nand2_1
X_6137_ _6138_/B _5460_/C _4496_/A _6136_/Y VDD VSS sg13cmos5l_o21ai_1
X_6068_ _6068_/Y _6068_/A _6068_/B VDD VSS sg13cmos5l_nor2_1
XFILLER_73_538 VDD VSS sg13cmos5l_decap_4
X_5019_ _5020_/B _5070_/A _5070_/B VDD VSS sg13cmos5l_xor2_1
XFILLER_38_270 VDD VSS sg13cmos5l_decap_8
XFILLER_45_229 VDD VSS sg13cmos5l_fill_1
XFILLER_54_730 VDD VSS sg13cmos5l_fill_1
XFILLER_42_914 VDD VSS sg13cmos5l_decap_8
XFILLER_81_582 VDD VSS sg13cmos5l_decap_8
XFILLER_41_402 VDD VSS sg13cmos5l_fill_1
XFILLER_41_435 VDD VSS sg13cmos5l_decap_4
XFILLER_42_55 VDD VSS sg13cmos5l_fill_1
XFILLER_77_833 VDD VSS sg13cmos5l_fill_1
XFILLER_77_822 VDD VSS sg13cmos5l_decap_8
XFILLER_67_63 VDD VSS sg13cmos5l_decap_8
XFILLER_77_877 VDD VSS sg13cmos5l_fill_1
XFILLER_76_365 VDD VSS sg13cmos5l_fill_2
XFILLER_36_207 VDD VSS sg13cmos5l_decap_8
XFILLER_57_590 VDD VSS sg13cmos5l_fill_2
XFILLER_45_741 VDD VSS sg13cmos5l_fill_1
XFILLER_45_785 VDD VSS sg13cmos5l_fill_1
XFILLER_44_284 VDD VSS sg13cmos5l_decap_8
XFILLER_66_4 VDD VSS sg13cmos5l_fill_2
X_5370_ _5429_/S _5430_/B1 _5858_/A _5370_/B1 _5683_/A VDD VSS sg13cmos5l_a22oi_1
X_4321_ _4322_/B _4433_/A _4640_/A _4375_/A _4122_/X VDD VSS sg13cmos5l_a22oi_1
X_4252_ _4252_/Y _4252_/A VDD VSS sg13cmos5l_inv_1
X_7040_ _7096_/C _7397_/A _7025_/Y _7313_/A _7327_/B VDD VSS sg13cmos5l_a22oi_1
XFILLER_68_800 VDD VSS sg13cmos5l_decap_8
XFILLER_79_170 VDD VSS sg13cmos5l_decap_8
X_4183_ _4230_/A _4181_/Y _4136_/B _4182_/Y VDD VSS sg13cmos5l_o21ai_1
XFILLER_68_844 VDD VSS sg13cmos5l_fill_2
XFILLER_82_302 VDD VSS sg13cmos5l_fill_2
XFILLER_55_505 VDD VSS sg13cmos5l_decap_8
XFILLER_82_368 VDD VSS sg13cmos5l_decap_4
XFILLER_35_251 VDD VSS sg13cmos5l_decap_4
X_6824_ _6824_/X _6824_/A _6927_/B VDD VSS sg13cmos5l_and2_1
X_3967_ _7661_/D _3967_/A _3970_/B VDD VSS sg13cmos5l_xnor2_1
X_6755_ _7004_/B _6753_/Y _6754_/Y _6813_/S VDD VSS sg13cmos5l_mux2_1
XFILLER_50_243 VDD VSS sg13cmos5l_fill_1
XFILLER_51_777 VDD VSS sg13cmos5l_fill_1
X_5706_ _5706_/Y _5809_/A _5706_/B VDD VSS sg13cmos5l_nor2_1
X_6686_ _6687_/A _6686_/A _6721_/A VDD VSS sg13cmos5l_nand2_2
XFILLER_12_14 VDD VSS sg13cmos5l_fill_2
X_5637_ _5690_/B _5872_/A _5637_/B VDD VSS sg13cmos5l_xnor2_1
XFILLER_88_18 VDD VSS sg13cmos5l_decap_8
X_5568_ _5568_/X _5568_/A VDD VSS sg13cmos5l_buf_1
X_7307_ _7555_/B _7307_/A _7307_/B VDD VSS sg13cmos5l_nand2_1
X_4519_ _4535_/A _4453_/B _4453_/A _4518_/Y VDD VSS sg13cmos5l_a21oi_1
XFILLER_5_8 VDD VSS sg13cmos5l_decap_8
X_5499_ _5500_/B _5499_/A _5554_/A VDD VSS sg13cmos5l_xnor2_1
X_7238_ _7238_/Y _7327_/A _7238_/B VDD VSS sg13cmos5l_nor2_1
XFILLER_59_833 VDD VSS sg13cmos5l_fill_1
XFILLER_59_855 VDD VSS sg13cmos5l_fill_2
X_7169_ _7169_/Y _7020_/A _7162_/B _7205_/A VDD VSS sg13cmos5l_a21oi_1
XFILLER_37_11 VDD VSS sg13cmos5l_decap_8
XFILLER_58_376 VDD VSS sg13cmos5l_fill_1
XFILLER_58_365 VDD VSS sg13cmos5l_decap_8
XFILLER_59_888 VDD VSS sg13cmos5l_fill_2
XFILLER_73_335 VDD VSS sg13cmos5l_fill_1
XFILLER_37_88 VDD VSS sg13cmos5l_decap_8
XFILLER_42_777 VDD VSS sg13cmos5l_fill_1
XFILLER_49_354 VDD VSS sg13cmos5l_fill_1
XFILLER_77_696 VDD VSS sg13cmos5l_fill_2
XFILLER_37_549 VDD VSS sg13cmos5l_fill_2
XFILLER_64_346 VDD VSS sg13cmos5l_fill_1
XFILLER_73_891 VDD VSS sg13cmos5l_fill_2
XFILLER_45_571 VDD VSS sg13cmos5l_fill_2
XFILLER_64_379 VDD VSS sg13cmos5l_decap_4
X_4870_ _4881_/A _5060_/A _4870_/B VDD VSS sg13cmos5l_xnor2_1
X_6540_ _6554_/B _7688_/Q VDD VSS sg13cmos5l_inv_1
X_6471_ _6473_/A _6471_/A _6842_/A VDD VSS sg13cmos5l_nand2_2
X_5422_ _5485_/A _5361_/B _5362_/A _5421_/Y VDD VSS sg13cmos5l_o21ai_1
X_5353_ _5363_/A _5364_/B _5364_/A VDD VSS sg13cmos5l_xor2_1
X_4304_ _4363_/B _4360_/A VDD VSS sg13cmos5l_inv_1
X_5284_ _5285_/B _5284_/A _5347_/B VDD VSS sg13cmos5l_xor2_1
X_4235_ _4236_/A _4235_/A VDD VSS sg13cmos5l_inv_1
X_7023_ _7023_/Y _7072_/B _6789_/Y _7022_/Y VDD VSS sg13cmos5l_o21ai_1
X_4166_ _4196_/A _4134_/B _4134_/A _4165_/Y VDD VSS sg13cmos5l_a21oi_1
XFILLER_82_110 VDD VSS sg13cmos5l_decap_8
XFILLER_68_685 VDD VSS sg13cmos5l_fill_2
X_4097_ _4138_/A _4139_/A _4097_/B VDD VSS sg13cmos5l_xor2_1
XFILLER_56_869 VDD VSS sg13cmos5l_decap_8
XFILLER_71_828 VDD VSS sg13cmos5l_decap_4
XFILLER_63_390 VDD VSS sg13cmos5l_decap_4
X_6807_ _6807_/Y _6900_/C _6807_/B VDD VSS sg13cmos5l_nor2_1
X_4999_ _5006_/A _5060_/A _4999_/B VDD VSS sg13cmos5l_xnor2_1
X_6738_ _6739_/A _6813_/S _6732_/Y _6737_/Y VDD VSS sg13cmos5l_o21ai_1
X_6669_ _6743_/B _6659_/B _7701_/Q VDD VSS sg13cmos5l_nand2b_1
XFILLER_59_641 VDD VSS sg13cmos5l_decap_8
XFILLER_74_600 VDD VSS sg13cmos5l_decap_4
XFILLER_46_302 VDD VSS sg13cmos5l_decap_4
XFILLER_46_335 VDD VSS sg13cmos5l_decap_4
XFILLER_47_869 VDD VSS sg13cmos5l_decap_4
XFILLER_58_195 VDD VSS sg13cmos5l_fill_2
XFILLER_62_817 VDD VSS sg13cmos5l_decap_8
XFILLER_61_338 VDD VSS sg13cmos5l_fill_1
XFILLER_80_74 VDD VSS sg13cmos5l_decap_8
XFILLER_69_416 VDD VSS sg13cmos5l_fill_2
X_4020_ _4032_/A _4168_/A _4020_/B VDD VSS sg13cmos5l_xnor2_1
XFILLER_29_4 VDD VSS sg13cmos5l_fill_1
XFILLER_38_825 VDD VSS sg13cmos5l_fill_1
XFILLER_37_357 VDD VSS sg13cmos5l_decap_8
XFILLER_80_603 VDD VSS sg13cmos5l_decap_4
X_5971_ _6018_/A _5971_/A _5971_/B _5971_/C VDD VSS sg13cmos5l_nand3_1
XFILLER_52_305 VDD VSS sg13cmos5l_fill_2
XFILLER_64_154 VDD VSS sg13cmos5l_decap_8
X_7710_ _7710_/Q clkload9/A _7710_/D fanout388/X VDD VSS sg13cmos5l_dfrbpq_1
X_4922_ _4923_/B _4922_/A _4922_/B VDD VSS sg13cmos5l_xnor2_1
X_7641_ _7643_/A _7641_/A _7641_/B VDD VSS sg13cmos5l_nand2_1
X_4853_ _4909_/A _4853_/A _4853_/B VDD VSS sg13cmos5l_nor2_1
X_7572_ _7621_/D _7572_/A _7572_/B VDD VSS sg13cmos5l_xnor2_1
X_4784_ _4786_/A _4784_/A _4790_/A VDD VSS sg13cmos5l_xnor2_1
XFILLER_60_393 VDD VSS sg13cmos5l_fill_1
X_6523_ _6524_/B _6521_/B _7685_/Q VDD VSS sg13cmos5l_nand2b_1
X_6454_ _6847_/B _6454_/A _6454_/B VDD VSS sg13cmos5l_nand2_2
X_5405_ _5406_/B _5405_/A _5472_/B VDD VSS sg13cmos5l_xor2_1
X_6385_ _6394_/A _6385_/A _6385_/B VDD VSS sg13cmos5l_nand2_2
X_5336_ _5336_/Y _5336_/A _5336_/B VDD VSS sg13cmos5l_nor2_1
X_5267_ _5318_/A _5212_/B _5212_/A _5266_/Y VDD VSS sg13cmos5l_a21oi_1
X_4218_ _4219_/C _4574_/A VDD VSS sg13cmos5l_inv_1
X_7006_ _7006_/Y _7006_/A _7030_/B VDD VSS sg13cmos5l_nand2_1
X_5198_ _5253_/A _5152_/B _5152_/A _5197_/Y VDD VSS sg13cmos5l_a21oi_1
XFILLER_56_611 VDD VSS sg13cmos5l_fill_1
X_4149_ _4235_/A _4149_/A _4149_/B VDD VSS sg13cmos5l_nor2_1
XFILLER_71_625 VDD VSS sg13cmos5l_fill_1
XFILLER_55_176 VDD VSS sg13cmos5l_decap_4
XFILLER_71_658 VDD VSS sg13cmos5l_fill_2
XFILLER_71_647 VDD VSS sg13cmos5l_fill_2
XFILLER_70_124 VDD VSS sg13cmos5l_decap_8
Xclkload0 clkload0/Y clkload0/A VDD VSS sg13cmos5l_inv_1
XFILLER_50_33 VDD VSS sg13cmos5l_decap_8
XFILLER_78_213 VDD VSS sg13cmos5l_decap_8
XFILLER_67_909 VDD VSS sg13cmos5l_fill_2
XFILLER_59_64 VDD VSS sg13cmos5l_fill_2
Xfanout270 _5519_/B _4944_/X VDD VSS sg13cmos5l_buf_1
XFILLER_47_611 VDD VSS sg13cmos5l_fill_1
Xfanout281 _7030_/B _6796_/X VDD VSS sg13cmos5l_buf_1
Xfanout292 _6516_/A _6290_/C VDD VSS sg13cmos5l_buf_2
XFILLER_59_482 VDD VSS sg13cmos5l_fill_2
XFILLER_46_132 VDD VSS sg13cmos5l_decap_8
XFILLER_47_655 VDD VSS sg13cmos5l_decap_4
XFILLER_74_463 VDD VSS sg13cmos5l_decap_8
XFILLER_46_154 VDD VSS sg13cmos5l_fill_1
XFILLER_62_658 VDD VSS sg13cmos5l_decap_8
XFILLER_61_168 VDD VSS sg13cmos5l_decap_8
XFILLER_42_371 VDD VSS sg13cmos5l_fill_1
X_6170_ _6170_/X _6170_/A _6170_/B VDD VSS sg13cmos5l_and2_1
X_5121_ _5122_/B _5245_/A _5121_/B VDD VSS sg13cmos5l_xnor2_1
X_5052_ _5053_/B _5245_/A _5052_/B VDD VSS sg13cmos5l_xnor2_1
X_4003_ _4004_/B _4205_/A VDD VSS sg13cmos5l_inv_4
XFILLER_37_165 VDD VSS sg13cmos5l_decap_8
XFILLER_65_485 VDD VSS sg13cmos5l_decap_8
XFILLER_80_455 VDD VSS sg13cmos5l_decap_8
X_5954_ _5955_/B _5954_/A _5973_/A VDD VSS sg13cmos5l_xnor2_1
X_5885_ _5885_/Y _5885_/A VDD VSS sg13cmos5l_inv_1
X_4905_ _4905_/Y _4905_/A _4841_/B VDD VSS sg13cmos5l_nor2b_1
X_4836_ _4840_/A _4900_/B _4836_/B VDD VSS sg13cmos5l_xnor2_1
X_7624_ _7625_/B _7624_/A _7624_/B _7624_/C _7624_/D VDD VSS sg13cmos5l_nand4_1
X_7555_ _7556_/B _7555_/A _7555_/B VDD VSS sg13cmos5l_nand2_1
X_4767_ _4768_/B _5014_/A _4947_/B _4767_/C VDD VSS sg13cmos5l_nor3_1
X_6506_ _6880_/B _6879_/B _6506_/B VDD VSS sg13cmos5l_nand2_2
Xrebuffer837 _6870_/A _6547_/A VDD VSS sg13cmos5l_buf_1
X_4698_ _4708_/A _4761_/A _4698_/B VDD VSS sg13cmos5l_xnor2_1
X_7486_ _7488_/A _7605_/A _7605_/B VDD VSS sg13cmos5l_nand2_2
XFILLER_20_25 VDD VSS sg13cmos5l_decap_4
X_6437_ _6438_/A _6434_/B _7675_/Q VDD VSS sg13cmos5l_nand2b_1
X_6368_ _6369_/A _6368_/A _6368_/B _6368_/C VDD VSS sg13cmos5l_nand3_1
XFILLER_96_18 VDD VSS sg13cmos5l_decap_8
X_5319_ _5344_/A _5283_/B _5283_/A _5318_/Y VDD VSS sg13cmos5l_a21oi_1
X_6299_ _6301_/A _6299_/A _6299_/B VDD VSS sg13cmos5l_nand2_2
XFILLER_49_909 VDD VSS sg13cmos5l_fill_2
XFILLER_69_780 VDD VSS sg13cmos5l_decap_8
XFILLER_72_912 VDD VSS sg13cmos5l_fill_2
XFILLER_56_463 VDD VSS sg13cmos5l_decap_8
XFILLER_71_411 VDD VSS sg13cmos5l_decap_8
XFILLER_44_658 VDD VSS sg13cmos5l_decap_8
XFILLER_71_477 VDD VSS sg13cmos5l_fill_1
XFILLER_45_99 VDD VSS sg13cmos5l_fill_2
XFILLER_40_853 VDD VSS sg13cmos5l_decap_8
XANTENNA_9 _4021_/A VDD VSS sg13cmos5l_antennanp
XFILLER_81_219 VDD VSS sg13cmos5l_decap_8
XFILLER_74_260 VDD VSS sg13cmos5l_fill_1
XFILLER_35_603 VDD VSS sg13cmos5l_fill_2
XFILLER_62_422 VDD VSS sg13cmos5l_fill_2
XFILLER_35_669 VDD VSS sg13cmos5l_decap_4
XFILLER_96_4 VDD VSS sg13cmos5l_decap_8
X_5670_ _5670_/Y _5670_/A VDD VSS sg13cmos5l_inv_1
X_4621_ _4622_/B _4621_/A _4621_/B VDD VSS sg13cmos5l_xnor2_1
X_7340_ _7342_/B _7352_/A _7347_/A VDD VSS sg13cmos5l_xnor2_1
X_4552_ _4552_/Y _4552_/A VDD VSS sg13cmos5l_inv_1
X_7271_ _7530_/A _7307_/B _7557_/B VDD VSS sg13cmos5l_xnor2_1
X_4483_ _4483_/Y _4483_/A _4464_/B VDD VSS sg13cmos5l_nor2b_1
X_6222_ _6222_/Y _6219_/A _6198_/Y _6221_/Y VDD VSS sg13cmos5l_o21ai_1
X_6153_ _6170_/A _6160_/B _6128_/B _6152_/Y VDD VSS sg13cmos5l_o21ai_1
X_5104_ _5104_/Y _5104_/A _5036_/A VDD VSS sg13cmos5l_nor2b_1
X_6084_ _6085_/B _6136_/B _5685_/X _6114_/B _5686_/X VDD VSS sg13cmos5l_a22oi_1
X_5035_ _5103_/A _5035_/A _5035_/B VDD VSS sg13cmos5l_and2_1
XFILLER_57_238 VDD VSS sg13cmos5l_decap_4
XFILLER_80_241 VDD VSS sg13cmos5l_decap_8
X_6986_ _7635_/A _7714_/Q _6986_/B VDD VSS sg13cmos5l_xnor2_1
XFILLER_81_786 VDD VSS sg13cmos5l_decap_8
X_5937_ _5938_/A _5937_/A VDD VSS sg13cmos5l_inv_1
X_7607_ _7608_/B _7607_/A _7607_/B VDD VSS sg13cmos5l_xnor2_1
X_5868_ _5874_/A _5982_/A _5868_/B VDD VSS sg13cmos5l_xnor2_1
Xrebuffer623 _7510_/A _7386_/A VDD VSS sg13cmos5l_buf_1
X_4819_ _4867_/A _4773_/B _4773_/A _4818_/Y VDD VSS sg13cmos5l_a21oi_1
X_5799_ _5800_/B _5799_/A _5852_/A VDD VSS sg13cmos5l_xnor2_1
Xrebuffer667 rebuffer667/X rebuffer668/X VDD VSS sg13cmos5l_buf_1
Xrebuffer634 rebuffer634/X rebuffer635/X VDD VSS sg13cmos5l_buf_1
X_7538_ _7614_/B _7538_/A _7538_/B VDD VSS sg13cmos5l_xor2_1
Xrebuffer645 _6798_/A _6299_/A VDD VSS sg13cmos5l_buf_1
Xrebuffer656 rebuffer656/X rebuffer657/X VDD VSS sg13cmos5l_buf_1
Xrebuffer678 rebuffer678/X rebuffer679/X VDD VSS sg13cmos5l_buf_1
X_7469_ _7473_/A _7469_/A _7475_/B VDD VSS sg13cmos5l_nor2b_1
Xrebuffer689 _7268_/A1 _7107_/Y VDD VSS sg13cmos5l_buf_1
Xinput102 _3946_/B quant_cfg[2] VDD VSS sg13cmos5l_buf_1
Xbank_A_sram.gen_ihp_256x32.u_sram_256x32_549 bank_A_sram.gen_ihp_256x32.u_sram_256x32/A_BM[1]
+ VDD VSS sg13cmos5l_tiehi
XFILLER_76_525 VDD VSS sg13cmos5l_fill_2
XFILLER_76_514 VDD VSS sg13cmos5l_fill_1
XFILLER_49_739 VDD VSS sg13cmos5l_fill_2
XFILLER_57_761 VDD VSS sg13cmos5l_fill_1
XFILLER_56_87 VDD VSS sg13cmos5l_fill_1
XFILLER_71_241 VDD VSS sg13cmos5l_fill_1
Xbank_B_sram.gen_ihp_256x32.u_sram_256x32_542 bank_B_sram.gen_ihp_256x32.u_sram_256x32_542/L_LO
+ VDD VSS sg13cmos5l_tielo
Xbank_B_sram.gen_ihp_256x32.u_sram_256x32_531 bank_B_sram.gen_ihp_256x32.u_sram_256x32_531/L_LO
+ VDD VSS sg13cmos5l_tielo
Xbank_B_sram.gen_ihp_256x32.u_sram_256x32_520 bank_B_sram.gen_ihp_256x32.u_sram_256x32_520/L_LO
+ VDD VSS sg13cmos5l_tielo
XFILLER_72_786 VDD VSS sg13cmos5l_fill_2
Xbank_B_sram.gen_ihp_256x32.u_sram_256x32_586 bank_B_sram.gen_ihp_256x32.u_sram_256x32/A_BM[4]
+ VDD VSS sg13cmos5l_tiehi
Xbank_B_sram.gen_ihp_256x32.u_sram_256x32_597 bank_B_sram.gen_ihp_256x32.u_sram_256x32_597/L_HI
+ VDD VSS sg13cmos5l_tiehi
XFILLER_40_650 VDD VSS sg13cmos5l_fill_1
XFILLER_40_672 VDD VSS sg13cmos5l_fill_2
XFILLER_79_352 VDD VSS sg13cmos5l_decap_8
XFILLER_39_238 VDD VSS sg13cmos5l_decap_8
XFILLER_54_208 VDD VSS sg13cmos5l_fill_2
X_6840_ _6840_/Y _6896_/B _6941_/A _6839_/Y VDD VSS sg13cmos5l_o21ai_1
XFILLER_63_742 VDD VSS sg13cmos5l_fill_2
XFILLER_63_753 VDD VSS sg13cmos5l_fill_1
X_6771_ _6771_/Y _6771_/A _6771_/B VDD VSS sg13cmos5l_xnor2_1
X_3983_ _3993_/A _5645_/A _3983_/B VDD VSS sg13cmos5l_xnor2_1
X_5722_ _5722_/Y _5722_/A VDD VSS sg13cmos5l_inv_1
X_5653_ _5657_/A _5653_/A _5723_/A VDD VSS sg13cmos5l_xnor2_1
X_5584_ _5709_/B _5710_/B VDD VSS sg13cmos5l_inv_1
X_4604_ _4614_/B _4604_/A _4604_/B VDD VSS sg13cmos5l_xor2_1
X_7323_ _7550_/B _7323_/A _7374_/B VDD VSS sg13cmos5l_nand2_2
X_4535_ _4599_/A _4535_/A _4598_/A VDD VSS sg13cmos5l_xnor2_1
XFILLER_117_27 VDD VSS sg13cmos5l_fill_2
X_7254_ _7254_/X _7253_/Y _7280_/A1 _7059_/Y VDD VSS sg13cmos5l_a21o_1
X_4466_ _4473_/B _4469_/B VDD VSS sg13cmos5l_inv_1
X_6205_ _6205_/Y _6212_/A _6205_/B VDD VSS sg13cmos5l_nor2_1
X_4397_ _4457_/A _4397_/A _4456_/A VDD VSS sg13cmos5l_xnor2_1
X_7185_ _7186_/A _7184_/B _7086_/Y _7184_/Y VDD VSS sg13cmos5l_o21ai_1
X_6136_ _6136_/Y _6136_/A _6136_/B VDD VSS sg13cmos5l_nand2_1
X_6067_ _6067_/Y _6067_/A VDD VSS sg13cmos5l_inv_1
X_5018_ _5070_/B _5080_/A _5018_/B VDD VSS sg13cmos5l_xnor2_1
XFILLER_39_783 VDD VSS sg13cmos5l_decap_8
XFILLER_26_24 VDD VSS sg13cmos5l_decap_4
XFILLER_54_764 VDD VSS sg13cmos5l_fill_2
XFILLER_81_561 VDD VSS sg13cmos5l_decap_8
X_6969_ _7078_/A _6811_/Y _6955_/B _6968_/X VDD VSS sg13cmos5l_a21oi_1
XFILLER_42_23 VDD VSS sg13cmos5l_fill_1
XFILLER_3_28 VDD VSS sg13cmos5l_fill_1
XFILLER_49_525 VDD VSS sg13cmos5l_decap_8
XFILLER_49_547 VDD VSS sg13cmos5l_decap_8
XFILLER_37_709 VDD VSS sg13cmos5l_fill_2
XFILLER_76_399 VDD VSS sg13cmos5l_fill_1
XFILLER_72_572 VDD VSS sg13cmos5l_decap_8
XFILLER_60_723 VDD VSS sg13cmos5l_fill_2
X_4320_ _4334_/A _4282_/B _4282_/A _4319_/Y VDD VSS sg13cmos5l_a21oi_1
X_4251_ _4295_/B _6022_/A _4251_/B VDD VSS sg13cmos5l_nor2_1
Xclkbuf_regs_0_clk_i clkbuf_regs_0_clk_i/X clk_i VDD VSS sg13cmos5l_buf_8
X_4182_ _4182_/Y _4135_/A _4182_/B VDD VSS sg13cmos5l_nand2b_1
XFILLER_67_366 VDD VSS sg13cmos5l_fill_1
XFILLER_103_18 VDD VSS sg13cmos5l_decap_8
XFILLER_82_336 VDD VSS sg13cmos5l_decap_4
XFILLER_67_388 VDD VSS sg13cmos5l_decap_8
XFILLER_36_720 VDD VSS sg13cmos5l_decap_8
XFILLER_35_274 VDD VSS sg13cmos5l_decap_8
XFILLER_51_723 VDD VSS sg13cmos5l_fill_1
XFILLER_51_734 VDD VSS sg13cmos5l_decap_8
X_6823_ _6824_/A _6823_/A _6823_/B VDD VSS sg13cmos5l_xnor2_1
X_3966_ _3970_/B _3966_/A _3966_/B _3966_/C VDD VSS sg13cmos5l_nand3_1
X_6754_ _6754_/Y _6754_/A _6754_/B VDD VSS sg13cmos5l_xnor2_1
X_5705_ _5809_/A _6136_/B VDD VSS sg13cmos5l_inv_1
X_6685_ _6721_/A _6685_/A _6687_/B VDD VSS sg13cmos5l_nor2b_1
X_5636_ _5637_/B _5985_/B1 _5943_/A2 _5949_/B1 _5943_/B2 VDD VSS sg13cmos5l_a22oi_1
X_5567_ _5593_/A _5526_/A _5565_/Y _5566_/Y VDD VSS sg13cmos5l_o21ai_1
X_7306_ _7308_/A _7306_/A _7307_/B VDD VSS sg13cmos5l_nand2_1
X_4518_ _4518_/Y _4518_/A _4518_/B VDD VSS sg13cmos5l_nor2_1
X_5498_ _5554_/A _5452_/B _5452_/A _5497_/X VDD VSS sg13cmos5l_a21oi_1
XFILLER_78_609 VDD VSS sg13cmos5l_fill_1
X_4449_ _4518_/A _4323_/X _4750_/A _4448_/Y VDD VSS sg13cmos5l_a21o_1
X_7237_ _7238_/B _7246_/A _7237_/B VDD VSS sg13cmos5l_nor2_1
XFILLER_58_322 VDD VSS sg13cmos5l_decap_8
X_7168_ _7168_/Y _7016_/B _7191_/B VDD VSS sg13cmos5l_nand2b_1
XFILLER_74_815 VDD VSS sg13cmos5l_decap_8
X_6119_ _6145_/A _6142_/B _6119_/B VDD VSS sg13cmos5l_xnor2_1
X_7099_ _7099_/Y _6877_/A _6877_/B _7134_/B VDD VSS sg13cmos5l_a21oi_1
XFILLER_59_867 VDD VSS sg13cmos5l_decap_4
XFILLER_37_67 VDD VSS sg13cmos5l_decap_8
XFILLER_73_347 VDD VSS sg13cmos5l_fill_2
XFILLER_54_550 VDD VSS sg13cmos5l_decap_8
XFILLER_81_380 VDD VSS sg13cmos5l_decap_8
XFILLER_41_222 VDD VSS sg13cmos5l_fill_2
XFILLER_53_44 VDD VSS sg13cmos5l_fill_2
XFILLER_54_583 VDD VSS sg13cmos5l_decap_4
XFILLER_78_52 VDD VSS sg13cmos5l_fill_2
XFILLER_49_322 VDD VSS sg13cmos5l_decap_8
XFILLER_37_528 VDD VSS sg13cmos5l_decap_8
XFILLER_65_837 VDD VSS sg13cmos5l_decap_8
XFILLER_65_848 VDD VSS sg13cmos5l_fill_1
XFILLER_60_553 VDD VSS sg13cmos5l_fill_2
XFILLER_60_597 VDD VSS sg13cmos5l_decap_8
X_6470_ _6842_/A _7679_/Q _6470_/B VDD VSS sg13cmos5l_xnor2_1
X_5421_ _5421_/Y _5357_/A _5359_/Y _5357_/B VDD VSS sg13cmos5l_o21ai_1
X_5352_ _5364_/A _5290_/B _5290_/A _5351_/X VDD VSS sg13cmos5l_a21o_1
X_4303_ _4360_/A _4563_/A _4303_/B VDD VSS sg13cmos5l_nand2_1
X_5283_ _5347_/B _5283_/A _5283_/B VDD VSS sg13cmos5l_xor2_1
X_7022_ _7022_/Y _6801_/Y _7072_/B _6796_/X VDD VSS sg13cmos5l_a21oi_1
X_4234_ _4234_/Y _4234_/A VDD VSS sg13cmos5l_inv_1
X_4165_ _4165_/Y _4165_/A _4165_/B VDD VSS sg13cmos5l_nor2_1
XFILLER_68_653 VDD VSS sg13cmos5l_fill_2
XFILLER_55_314 VDD VSS sg13cmos5l_decap_8
X_4096_ _4139_/A _4064_/Y _4072_/A _4095_/Y VDD VSS sg13cmos5l_a21o_1
XFILLER_36_561 VDD VSS sg13cmos5l_fill_2
XFILLER_82_199 VDD VSS sg13cmos5l_fill_1
XFILLER_36_594 VDD VSS sg13cmos5l_decap_8
X_6806_ _6807_/B _6977_/B _6803_/Y _6978_/B _6805_/Y VDD VSS sg13cmos5l_a22oi_1
X_4998_ _4999_/B _5310_/B1 _5568_/A _5244_/B1 _5569_/A VDD VSS sg13cmos5l_a22oi_1
X_3949_ _3950_/A _3949_/A VDD VSS sg13cmos5l_buf_1
X_6737_ _6737_/Y _6904_/B _6910_/S VDD VSS sg13cmos5l_nand2_1
XFILLER_99_18 VDD VSS sg13cmos5l_decap_8
X_6668_ _6742_/A _6668_/A VDD VSS sg13cmos5l_inv_1
X_6599_ _6764_/A _6599_/A _6601_/B VDD VSS sg13cmos5l_nor2b_1
X_5619_ _5619_/Y _5619_/A _5563_/A VDD VSS sg13cmos5l_nor2b_1
XFILLER_79_907 VDD VSS sg13cmos5l_fill_2
XFILLER_78_406 VDD VSS sg13cmos5l_fill_1
XFILLER_48_22 VDD VSS sg13cmos5l_fill_1
XFILLER_48_44 VDD VSS sg13cmos5l_decap_4
XFILLER_48_99 VDD VSS sg13cmos5l_decap_8
XFILLER_58_174 VDD VSS sg13cmos5l_decap_8
XFILLER_73_122 VDD VSS sg13cmos5l_decap_8
XFILLER_46_347 VDD VSS sg13cmos5l_decap_8
XFILLER_46_358 VDD VSS sg13cmos5l_fill_2
XFILLER_69_439 VDD VSS sg13cmos5l_decap_8
XFILLER_49_174 VDD VSS sg13cmos5l_decap_4
XFILLER_37_336 VDD VSS sg13cmos5l_decap_8
XFILLER_49_196 VDD VSS sg13cmos5l_decap_4
XFILLER_53_807 VDD VSS sg13cmos5l_fill_1
X_5970_ _5972_/A _5971_/A _5971_/B _5971_/C VDD VSS sg13cmos5l_a21oi_1
XFILLER_53_829 VDD VSS sg13cmos5l_decap_8
X_4921_ _4922_/B _5117_/B1 _5118_/A _5050_/B1 _5119_/A VDD VSS sg13cmos5l_a22oi_1
X_7640_ _7723_/D _7640_/A _7658_/B VDD VSS sg13cmos5l_nand2_2
X_4852_ _4853_/B _4852_/A VDD VSS sg13cmos5l_inv_1
XFILLER_60_350 VDD VSS sg13cmos5l_decap_4
XFILLER_61_884 VDD VSS sg13cmos5l_decap_8
X_7571_ _7572_/B _7571_/A _7571_/B VDD VSS sg13cmos5l_nand2_1
X_4783_ _4790_/A _4792_/A _4791_/A VDD VSS sg13cmos5l_xnor2_1
X_6522_ _6524_/A _6883_/B _6883_/A VDD VSS sg13cmos5l_nand2_2
X_6453_ _6454_/A _6453_/A _6848_/A VDD VSS sg13cmos5l_nand2_2
X_5404_ _5472_/B _5404_/A _5404_/B VDD VSS sg13cmos5l_xor2_1
X_6384_ _6385_/B _6382_/B _7670_/Q VDD VSS sg13cmos5l_nand2b_1
X_5335_ _5336_/B _5460_/A _5460_/B _5335_/C VDD VSS sg13cmos5l_nor3_1
X_5266_ _5266_/Y _5266_/A _5266_/B VDD VSS sg13cmos5l_nor2_1
X_4217_ _4220_/A _3929_/X _4574_/A _4387_/A VDD VSS sg13cmos5l_a21oi_1
X_7005_ _7006_/A _6739_/A _7044_/A _7004_/Y VDD VSS sg13cmos5l_a21oi_1
X_5197_ _5197_/Y _5197_/A _5197_/B VDD VSS sg13cmos5l_nor2_1
XFILLER_68_461 VDD VSS sg13cmos5l_decap_4
XFILLER_18_25 VDD VSS sg13cmos5l_decap_4
XFILLER_56_623 VDD VSS sg13cmos5l_fill_1
X_4148_ _4149_/B _4148_/A VDD VSS sg13cmos5l_inv_1
XFILLER_56_634 VDD VSS sg13cmos5l_decap_8
X_4079_ _4079_/Y _4079_/A _4079_/B VDD VSS sg13cmos5l_nor2_1
XFILLER_43_306 VDD VSS sg13cmos5l_fill_2
XFILLER_56_667 VDD VSS sg13cmos5l_fill_2
XFILLER_43_328 VDD VSS sg13cmos5l_decap_8
XFILLER_70_136 VDD VSS sg13cmos5l_fill_2
Xclkload1 clkload1/Y clkload1/A VDD VSS sg13cmos5l_inv_1
XFILLER_50_12 VDD VSS sg13cmos5l_fill_1
XFILLER_50_45 VDD VSS sg13cmos5l_decap_4
XFILLER_50_56 VDD VSS sg13cmos5l_fill_1
XFILLER_59_32 VDD VSS sg13cmos5l_decap_8
XFILLER_78_269 VDD VSS sg13cmos5l_decap_8
XFILLER_75_910 VDD VSS sg13cmos5l_fill_2
Xfanout260 _6960_/B _6968_/B VDD VSS sg13cmos5l_buf_1
XFILLER_47_623 VDD VSS sg13cmos5l_fill_2
Xfanout271 _5118_/A _4563_/X VDD VSS sg13cmos5l_buf_1
Xfanout282 _7397_/A _6785_/X VDD VSS sg13cmos5l_buf_1
Xfanout293 _6085_/A _6110_/B VDD VSS sg13cmos5l_buf_1
XFILLER_74_486 VDD VSS sg13cmos5l_fill_1
XFILLER_61_125 VDD VSS sg13cmos5l_fill_2
XFILLER_43_851 VDD VSS sg13cmos5l_decap_4
XFILLER_61_136 VDD VSS sg13cmos5l_decap_8
X_5120_ _5121_/B _5310_/B1 _5685_/A _5244_/B1 _5686_/A VDD VSS sg13cmos5l_a22oi_1
X_5051_ _5052_/B _5244_/B1 _5118_/A _5178_/B1 _5119_/A VDD VSS sg13cmos5l_a22oi_1
X_4002_ _4005_/B _3955_/A _4205_/A _4387_/A VDD VSS sg13cmos5l_a21oi_1
XFILLER_65_442 VDD VSS sg13cmos5l_fill_1
XFILLER_81_924 VDD VSS sg13cmos5l_decap_8
XFILLER_37_144 VDD VSS sg13cmos5l_decap_8
XFILLER_80_434 VDD VSS sg13cmos5l_decap_8
XFILLER_53_637 VDD VSS sg13cmos5l_fill_1
XFILLER_53_659 VDD VSS sg13cmos5l_decap_8
X_5953_ _5973_/A _5905_/B _5906_/A _5903_/Y VDD VSS sg13cmos5l_a21oi_1
X_5884_ _5933_/B _6128_/A _5884_/B VDD VSS sg13cmos5l_xnor2_1
X_4904_ _4969_/B _4904_/A _4904_/B VDD VSS sg13cmos5l_xor2_1
X_4835_ _4836_/B _4835_/A _4901_/B VDD VSS sg13cmos5l_xor2_1
XFILLER_61_692 VDD VSS sg13cmos5l_decap_4
X_7623_ _7624_/D _7623_/A _7623_/B _7623_/C _7623_/D VDD VSS sg13cmos5l_nor4_1
X_7554_ _7555_/A _7554_/A _7554_/B VDD VSS sg13cmos5l_nand2_1
X_4766_ _4767_/C _5131_/A VDD VSS sg13cmos5l_inv_1
X_6505_ _6879_/B _6505_/A _6505_/B _6836_/B VDD VSS sg13cmos5l_nand3_1
Xrebuffer838 _6765_/B _6592_/A VDD VSS sg13cmos5l_buf_1
X_4697_ _4698_/B _4811_/A _5199_/A _4750_/A _5200_/A VDD VSS sg13cmos5l_a22oi_1
X_7485_ _7609_/A _7485_/A _7485_/B VDD VSS sg13cmos5l_nand2_2
X_6436_ _6438_/B _6436_/A _6436_/B _6820_/B VDD VSS sg13cmos5l_nand3_1
X_6367_ _6367_/Y _6368_/A _6368_/C _6368_/B VDD VSS sg13cmos5l_a21oi_1
X_5318_ _5318_/Y _5318_/A _5282_/B VDD VSS sg13cmos5l_nor2b_1
X_6298_ _6299_/A _6298_/A _7662_/Q VDD VSS sg13cmos5l_xnor2_1
X_5249_ _5249_/X _5249_/A _5249_/B VDD VSS sg13cmos5l_and2_1
XFILLER_68_291 VDD VSS sg13cmos5l_decap_8
XFILLER_56_453 VDD VSS sg13cmos5l_decap_4
XFILLER_44_637 VDD VSS sg13cmos5l_decap_8
XFILLER_45_56 VDD VSS sg13cmos5l_fill_1
XFILLER_43_169 VDD VSS sg13cmos5l_fill_2
XFILLER_61_22 VDD VSS sg13cmos5l_fill_2
XFILLER_61_55 VDD VSS sg13cmos5l_decap_8
XFILLER_67_729 VDD VSS sg13cmos5l_fill_2
XFILLER_66_228 VDD VSS sg13cmos5l_decap_8
XFILLER_13_8 VDD VSS sg13cmos5l_decap_8
XFILLER_47_431 VDD VSS sg13cmos5l_decap_8
XFILLER_47_442 VDD VSS sg13cmos5l_fill_1
XFILLER_43_681 VDD VSS sg13cmos5l_decap_4
X_4620_ _4621_/B _4799_/B1 _5118_/A _4738_/B1 _5119_/A VDD VSS sg13cmos5l_a22oi_1
X_4551_ _4606_/B _4551_/A VDD VSS sg13cmos5l_inv_1
X_7270_ _7557_/B _6416_/A _7267_/Y _7269_/X VDD VSS sg13cmos5l_o21ai_1
X_4482_ _4544_/A _4482_/A _4482_/B VDD VSS sg13cmos5l_nor2_1
X_6221_ _6221_/Y _6223_/A _6221_/B VDD VSS sg13cmos5l_nand2_1
XFILLER_106_18 VDD VSS sg13cmos5l_decap_8
X_6152_ _6152_/Y _6152_/A _6152_/B VDD VSS sg13cmos5l_nand2_1
XFILLER_32_0 VDD VSS sg13cmos5l_fill_1
X_5103_ _5104_/A _5103_/A VDD VSS sg13cmos5l_inv_1
XFILLER_58_707 VDD VSS sg13cmos5l_decap_4
X_6083_ _6117_/B _6083_/A VDD VSS sg13cmos5l_inv_1
X_5034_ _5036_/A _5040_/B _5040_/A VDD VSS sg13cmos5l_xor2_1
XFILLER_81_765 VDD VSS sg13cmos5l_decap_8
XFILLER_80_220 VDD VSS sg13cmos5l_decap_8
X_6985_ _6986_/B _6985_/A _6988_/C VDD VSS sg13cmos5l_nand2_2
XFILLER_53_434 VDD VSS sg13cmos5l_decap_4
XFILLER_65_294 VDD VSS sg13cmos5l_decap_4
X_5936_ _5971_/A _5936_/A _5936_/B _5936_/C VDD VSS sg13cmos5l_nand3_1
XFILLER_80_297 VDD VSS sg13cmos5l_decap_8
X_7606_ _7607_/B _7604_/Y _7606_/B VDD VSS sg13cmos5l_nand2b_1
X_5867_ _5868_/B _6058_/B1 _5941_/A2 _6026_/B1 _5941_/B2 VDD VSS sg13cmos5l_a22oi_1
Xrebuffer624 _7519_/A rebuffer682/X VDD VSS sg13cmos5l_buf_1
X_4818_ _4818_/Y _4818_/A _4818_/B VDD VSS sg13cmos5l_nor2_1
X_5798_ _5852_/A _5767_/B _5767_/A _5797_/X VDD VSS sg13cmos5l_a21oi_1
Xrebuffer635 rebuffer635/X rebuffer636/X VDD VSS sg13cmos5l_buf_1
X_7537_ _7538_/B _7537_/A _7537_/B VDD VSS sg13cmos5l_nand2_1
Xrebuffer646 _7225_/A rebuffer648/X VDD VSS sg13cmos5l_buf_1
Xrebuffer657 rebuffer657/X _6909_/A VDD VSS sg13cmos5l_buf_1
X_4749_ _4758_/A _4749_/A _4749_/B VDD VSS sg13cmos5l_xnor2_1
Xrebuffer679 rebuffer679/X rebuffer726/X VDD VSS sg13cmos5l_buf_1
Xrebuffer668 rebuffer668/X rebuffer669/X VDD VSS sg13cmos5l_buf_1
X_7468_ _7475_/B _7598_/B _7597_/A VDD VSS sg13cmos5l_and2_1
X_6419_ _6420_/A _7289_/A _6698_/B VDD VSS sg13cmos5l_nor2_1
X_7399_ _7399_/Y _7399_/A VDD VSS sg13cmos5l_inv_1
Xinput103 _3995_/B quant_cfg[4] VDD VSS sg13cmos5l_buf_1
Xbank_B_sram.gen_ihp_256x32.u_sram_256x32_510 bank_B_sram.gen_ihp_256x32.u_sram_256x32_510/L_LO
+ VDD VSS sg13cmos5l_tielo
XFILLER_44_401 VDD VSS sg13cmos5l_fill_2
Xbank_B_sram.gen_ihp_256x32.u_sram_256x32_543 bank_B_sram.gen_ihp_256x32.u_sram_256x32_543/L_LO
+ VDD VSS sg13cmos5l_tielo
Xbank_B_sram.gen_ihp_256x32.u_sram_256x32_532 bank_B_sram.gen_ihp_256x32.u_sram_256x32_532/L_LO
+ VDD VSS sg13cmos5l_tielo
Xbank_B_sram.gen_ihp_256x32.u_sram_256x32_521 bank_B_sram.gen_ihp_256x32.u_sram_256x32_521/L_LO
+ VDD VSS sg13cmos5l_tielo
XFILLER_71_275 VDD VSS sg13cmos5l_fill_1
Xclkbuf_1_0__f_clk_i clkbuf_1_0__f_clk_i/X clkbuf_0_clk_i/X VDD VSS sg13cmos5l_buf_8
Xbank_B_sram.gen_ihp_256x32.u_sram_256x32_587 bank_B_sram.gen_ihp_256x32.u_sram_256x32/A_BM[5]
+ VDD VSS sg13cmos5l_tiehi
Xbank_B_sram.gen_ihp_256x32.u_sram_256x32_598 bank_B_sram.gen_ihp_256x32.u_sram_256x32_598/L_HI
+ VDD VSS sg13cmos5l_tiehi
XFILLER_79_331 VDD VSS sg13cmos5l_decap_8
XFILLER_67_537 VDD VSS sg13cmos5l_fill_2
XFILLER_82_529 VDD VSS sg13cmos5l_decap_8
XFILLER_75_570 VDD VSS sg13cmos5l_decap_8
XFILLER_47_294 VDD VSS sg13cmos5l_fill_2
X_3982_ _3983_/B _3937_/A _4529_/A _3999_/B _4530_/A VDD VSS sg13cmos5l_a22oi_1
X_6770_ _6770_/Y _6769_/Y _6770_/B VDD VSS sg13cmos5l_nand2b_1
X_5721_ _5776_/A _5721_/A _5721_/B VDD VSS sg13cmos5l_xor2_1
X_5652_ _5723_/A _5652_/A _5722_/A VDD VSS sg13cmos5l_xor2_1
X_5583_ _5710_/B _5460_/A _5643_/A _5520_/Y VDD VSS sg13cmos5l_a21oi_1
X_4603_ _4604_/B _4662_/B _4662_/A VDD VSS sg13cmos5l_xor2_1
X_7322_ _7347_/B _7324_/B VDD VSS sg13cmos5l_buf_4
X_4534_ _4598_/A _4534_/A _4534_/B VDD VSS sg13cmos5l_xor2_1
X_7253_ _7253_/Y _7253_/A1 _7294_/B _7182_/A VDD VSS sg13cmos5l_a21oi_1
X_4465_ _4469_/B _4481_/A _4480_/A VDD VSS sg13cmos5l_xnor2_1
X_4396_ _4456_/A _4396_/A _4396_/B VDD VSS sg13cmos5l_xor2_1
X_6204_ _6204_/Y _6204_/A VDD VSS sg13cmos5l_inv_1
X_7184_ _7184_/Y _7184_/A _7184_/B VDD VSS sg13cmos5l_nand2_1
X_6135_ _6149_/B _6135_/A _6135_/B VDD VSS sg13cmos5l_nand2_1
X_6066_ _6070_/A _6093_/B _6093_/A VDD VSS sg13cmos5l_xor2_1
XFILLER_58_526 VDD VSS sg13cmos5l_decap_8
XFILLER_73_507 VDD VSS sg13cmos5l_decap_8
X_5017_ _5018_/B _5257_/A _5081_/A _5190_/A _5082_/A VDD VSS sg13cmos5l_a22oi_1
XFILLER_66_581 VDD VSS sg13cmos5l_decap_8
XFILLER_81_540 VDD VSS sg13cmos5l_decap_8
XFILLER_66_592 VDD VSS sg13cmos5l_fill_2
XFILLER_54_754 VDD VSS sg13cmos5l_fill_1
XFILLER_53_253 VDD VSS sg13cmos5l_decap_8
X_6968_ _6968_/X _6968_/A _6968_/B VDD VSS sg13cmos5l_and2_1
X_6899_ _6991_/B _6899_/A _6899_/B _6913_/B VDD VSS sg13cmos5l_nand3_1
X_5919_ _5962_/B _5878_/B _5878_/A _5918_/Y VDD VSS sg13cmos5l_a21oi_1
XFILLER_77_868 VDD VSS sg13cmos5l_decap_8
XFILLER_67_87 VDD VSS sg13cmos5l_decap_8
XFILLER_76_389 VDD VSS sg13cmos5l_fill_2
XFILLER_64_529 VDD VSS sg13cmos5l_decap_8
XFILLER_57_592 VDD VSS sg13cmos5l_fill_1
XFILLER_45_776 VDD VSS sg13cmos5l_decap_8
XFILLER_60_713 VDD VSS sg13cmos5l_decap_4
XFILLER_60_768 VDD VSS sg13cmos5l_fill_2
X_4250_ _4345_/A _4250_/A _4250_/B VDD VSS sg13cmos5l_nand2_1
X_4181_ _4181_/Y _4181_/A VDD VSS sg13cmos5l_inv_1
XFILLER_68_846 VDD VSS sg13cmos5l_fill_1
XFILLER_68_879 VDD VSS sg13cmos5l_decap_8
XFILLER_67_345 VDD VSS sg13cmos5l_decap_8
XFILLER_82_359 VDD VSS sg13cmos5l_decap_4
XFILLER_36_754 VDD VSS sg13cmos5l_decap_4
XFILLER_63_540 VDD VSS sg13cmos5l_decap_8
XFILLER_36_787 VDD VSS sg13cmos5l_decap_4
XFILLER_35_242 VDD VSS sg13cmos5l_decap_4
X_6822_ _6822_/X _6822_/A _6822_/B VDD VSS sg13cmos5l_xor2_1
XFILLER_63_573 VDD VSS sg13cmos5l_fill_2
XFILLER_50_201 VDD VSS sg13cmos5l_fill_2
XFILLER_63_595 VDD VSS sg13cmos5l_decap_4
X_3965_ _3966_/C _4327_/B _3965_/B VDD VSS sg13cmos5l_nand2_1
X_6753_ _6753_/Y _6753_/A _6753_/B VDD VSS sg13cmos5l_xnor2_1
X_5704_ _5719_/A _5704_/A _5704_/B VDD VSS sg13cmos5l_xor2_1
X_6684_ _6687_/B _6684_/A _7704_/Q _6684_/C VDD VSS sg13cmos5l_nand3_1
X_5635_ _5690_/A _5870_/A _5635_/B VDD VSS sg13cmos5l_xnor2_1
XFILLER_12_16 VDD VSS sg13cmos5l_fill_1
X_5566_ _5566_/Y _5566_/A _5566_/B VDD VSS sg13cmos5l_nand2_1
X_7305_ _7305_/Y _7557_/B _7303_/B _7352_/A VDD VSS sg13cmos5l_a21oi_1
X_5497_ _5497_/X _5497_/A _5497_/B VDD VSS sg13cmos5l_and2_1
X_4517_ _4599_/B _4517_/A _4517_/B VDD VSS sg13cmos5l_xor2_1
X_4448_ _4448_/Y _4448_/A _4448_/B VDD VSS sg13cmos5l_nor2_1
X_7236_ _7376_/B _7246_/A _7031_/Y _7235_/Y VDD VSS sg13cmos5l_o21ai_1
X_7167_ _7167_/Y _7167_/A _7167_/B VDD VSS sg13cmos5l_nand2_1
XFILLER_59_824 VDD VSS sg13cmos5l_decap_8
X_4379_ _4426_/B _4875_/A _4379_/B VDD VSS sg13cmos5l_xnor2_1
X_7098_ _7160_/A _7108_/S VDD VSS sg13cmos5l_buf_1
X_6118_ _6119_/B _5781_/X _6117_/B _6117_/Y VDD VSS sg13cmos5l_o21ai_1
XFILLER_37_46 VDD VSS sg13cmos5l_decap_8
X_6049_ _6049_/X _6049_/A _6049_/B VDD VSS sg13cmos5l_and2_1
XFILLER_82_871 VDD VSS sg13cmos5l_fill_1
XFILLER_41_201 VDD VSS sg13cmos5l_decap_8
XFILLER_54_595 VDD VSS sg13cmos5l_decap_4
XFILLER_42_768 VDD VSS sg13cmos5l_decap_4
XFILLER_41_278 VDD VSS sg13cmos5l_fill_1
XFILLER_78_42 VDD VSS sg13cmos5l_decap_8
XFILLER_49_301 VDD VSS sg13cmos5l_fill_1
XFILLER_76_120 VDD VSS sg13cmos5l_fill_2
XFILLER_49_345 VDD VSS sg13cmos5l_decap_8
XFILLER_65_816 VDD VSS sg13cmos5l_fill_2
XFILLER_77_698 VDD VSS sg13cmos5l_fill_1
XFILLER_49_367 VDD VSS sg13cmos5l_decap_8
XFILLER_64_359 VDD VSS sg13cmos5l_fill_2
XFILLER_45_573 VDD VSS sg13cmos5l_fill_1
XFILLER_71_4 VDD VSS sg13cmos5l_fill_1
X_5420_ _5485_/B _5420_/A _5420_/B VDD VSS sg13cmos5l_xnor2_1
X_5351_ _5351_/X _5351_/A _5351_/B VDD VSS sg13cmos5l_and2_1
X_5282_ _5283_/B _5318_/A _5282_/B VDD VSS sg13cmos5l_xnor2_1
X_4302_ _4563_/A _4302_/A VDD VSS sg13cmos5l_buf_1
X_4233_ _4350_/A _4234_/A _4233_/B _4248_/A VDD VSS sg13cmos5l_nor3_1
X_7021_ _7078_/B _7021_/A VDD VSS sg13cmos5l_buf_1
XFILLER_59_109 VDD VSS sg13cmos5l_fill_2
XFILLER_68_632 VDD VSS sg13cmos5l_fill_2
XFILLER_114_18 VDD VSS sg13cmos5l_decap_8
X_4164_ _4180_/A _4194_/A _4194_/B VDD VSS sg13cmos5l_xor2_1
XFILLER_82_101 VDD VSS sg13cmos5l_decap_4
X_4095_ _4095_/Y _4095_/A _4064_/A VDD VSS sg13cmos5l_nor2b_1
XFILLER_68_687 VDD VSS sg13cmos5l_fill_1
XFILLER_67_153 VDD VSS sg13cmos5l_fill_1
XFILLER_82_134 VDD VSS sg13cmos5l_decap_4
XFILLER_71_819 VDD VSS sg13cmos5l_decap_4
XFILLER_64_871 VDD VSS sg13cmos5l_fill_2
XFILLER_36_573 VDD VSS sg13cmos5l_decap_8
XFILLER_51_510 VDD VSS sg13cmos5l_fill_1
X_6805_ _6805_/Y _6805_/A _6805_/B VDD VSS sg13cmos5l_xnor2_1
XFILLER_23_15 VDD VSS sg13cmos5l_decap_8
X_6736_ _6955_/B _6941_/B VDD VSS sg13cmos5l_buf_1
X_4997_ _4997_/X _4997_/A VDD VSS sg13cmos5l_buf_1
X_3948_ _3949_/A _5706_/B _3948_/B VDD VSS sg13cmos5l_nor2_1
X_6667_ _6668_/A _6676_/B _6676_/A VDD VSS sg13cmos5l_nor2_1
X_5618_ _5674_/A _5618_/A _5618_/B _5618_/C VDD VSS sg13cmos5l_nand3_1
X_6598_ _6601_/B _6598_/A _7694_/Q _6641_/C VDD VSS sg13cmos5l_nand3_1
X_5549_ _5550_/B _5480_/B _5788_/A _5548_/Y VDD VSS sg13cmos5l_a21oi_1
XFILLER_79_919 VDD VSS sg13cmos5l_decap_8
X_7219_ _7219_/Y _7219_/A _7246_/A VDD VSS sg13cmos5l_nand2_1
XFILLER_48_67 VDD VSS sg13cmos5l_decap_8
XFILLER_58_120 VDD VSS sg13cmos5l_fill_1
XFILLER_59_665 VDD VSS sg13cmos5l_fill_2
XFILLER_46_315 VDD VSS sg13cmos5l_decap_4
XFILLER_47_816 VDD VSS sg13cmos5l_fill_2
XFILLER_73_112 VDD VSS sg13cmos5l_fill_2
XFILLER_58_197 VDD VSS sg13cmos5l_fill_1
XFILLER_73_156 VDD VSS sg13cmos5l_decap_8
XFILLER_55_860 VDD VSS sg13cmos5l_fill_1
XFILLER_64_33 VDD VSS sg13cmos5l_decap_8
XFILLER_55_882 VDD VSS sg13cmos5l_decap_8
XFILLER_61_329 VDD VSS sg13cmos5l_fill_2
XFILLER_70_852 VDD VSS sg13cmos5l_decap_8
XFILLER_9_28 VDD VSS sg13cmos5l_fill_1
XFILLER_69_418 VDD VSS sg13cmos5l_fill_1
XFILLER_77_440 VDD VSS sg13cmos5l_decap_4
XFILLER_49_131 VDD VSS sg13cmos5l_decap_8
XFILLER_37_315 VDD VSS sg13cmos5l_decap_8
XFILLER_49_153 VDD VSS sg13cmos5l_decap_8
XFILLER_52_307 VDD VSS sg13cmos5l_fill_1
XFILLER_65_679 VDD VSS sg13cmos5l_decap_4
X_4920_ _4985_/S _4986_/B1 _4737_/X _4920_/B1 _5116_/A VDD VSS sg13cmos5l_a22oi_1
X_4851_ _4853_/A _4851_/A VDD VSS sg13cmos5l_inv_1
XFILLER_61_863 VDD VSS sg13cmos5l_decap_8
X_7570_ _7571_/B _7570_/A _7570_/B VDD VSS sg13cmos5l_nand2_1
X_4782_ _4791_/A _4794_/A _4782_/B VDD VSS sg13cmos5l_xnor2_1
X_6521_ _6883_/A _7685_/Q _6521_/B VDD VSS sg13cmos5l_xnor2_1
X_6452_ _6848_/A _6452_/A _6454_/B VDD VSS sg13cmos5l_nor2b_1
X_5403_ _5404_/B _5438_/A _5403_/B VDD VSS sg13cmos5l_xnor2_1
X_6383_ _6385_/A _6814_/B _6814_/A VDD VSS sg13cmos5l_nand2_2
X_5334_ _5335_/C _5698_/A VDD VSS sg13cmos5l_inv_1
X_5265_ _5283_/A _5265_/A _5265_/B VDD VSS sg13cmos5l_xor2_1
X_4216_ _4574_/A _4216_/A VDD VSS sg13cmos5l_buf_1
X_7004_ _7004_/Y _7004_/A _7004_/B VDD VSS sg13cmos5l_nor2_1
X_5196_ _5214_/A _5196_/A _5196_/B VDD VSS sg13cmos5l_xor2_1
X_4147_ _4149_/A _4147_/A VDD VSS sg13cmos5l_inv_1
XFILLER_55_123 VDD VSS sg13cmos5l_decap_8
XFILLER_55_134 VDD VSS sg13cmos5l_fill_2
XFILLER_71_605 VDD VSS sg13cmos5l_fill_2
X_4078_ _4110_/B _4207_/A _4078_/B VDD VSS sg13cmos5l_xnor2_1
XFILLER_44_819 VDD VSS sg13cmos5l_decap_8
XFILLER_37_893 VDD VSS sg13cmos5l_decap_8
XFILLER_52_830 VDD VSS sg13cmos5l_fill_1
XFILLER_34_14 VDD VSS sg13cmos5l_decap_8
Xclkload2 clkload2/Y clkload2/A VDD VSS sg13cmos5l_inv_1
X_7699_ _7699_/Q _7724_/CLK _7699_/D fanout384/X VDD VSS sg13cmos5l_dfrbpq_1
X_6719_ _7105_/A _6990_/A _7004_/A _6990_/C VDD VSS sg13cmos5l_nand3_1
XFILLER_79_716 VDD VSS sg13cmos5l_decap_8
XFILLER_59_66 VDD VSS sg13cmos5l_fill_1
XFILLER_78_248 VDD VSS sg13cmos5l_decap_8
Xfanout250 _4529_/A _3950_/X VDD VSS sg13cmos5l_buf_1
Xfanout261 _7162_/B _7187_/A VDD VSS sg13cmos5l_buf_1
Xfanout283 _6996_/A _6747_/X VDD VSS sg13cmos5l_buf_1
Xfanout272 _4996_/A _4429_/X VDD VSS sg13cmos5l_buf_1
XFILLER_75_933 VDD VSS sg13cmos5l_fill_1
XFILLER_74_421 VDD VSS sg13cmos5l_decap_8
XFILLER_46_101 VDD VSS sg13cmos5l_decap_8
Xfanout294 _6042_/A _5781_/X VDD VSS sg13cmos5l_buf_1
XFILLER_59_484 VDD VSS sg13cmos5l_fill_1
XFILLER_74_454 VDD VSS sg13cmos5l_fill_2
XFILLER_70_671 VDD VSS sg13cmos5l_fill_2
XFILLER_43_896 VDD VSS sg13cmos5l_fill_2
XFILLER_40_90 VDD VSS sg13cmos5l_decap_8
X_5050_ _5115_/S _5117_/B1 _5309_/A _5050_/B1 _5116_/A VDD VSS sg13cmos5l_a22oi_1
X_4001_ _4205_/A _4001_/A VDD VSS sg13cmos5l_buf_16
XFILLER_77_292 VDD VSS sg13cmos5l_decap_4
XFILLER_66_933 VDD VSS sg13cmos5l_fill_1
XFILLER_37_123 VDD VSS sg13cmos5l_decap_8
XFILLER_80_402 VDD VSS sg13cmos5l_decap_8
X_5952_ _5954_/A _5984_/S _5952_/B VDD VSS sg13cmos5l_xnor2_1
X_4903_ _4904_/B _4963_/B _4963_/A VDD VSS sg13cmos5l_xor2_1
XFILLER_46_690 VDD VSS sg13cmos5l_decap_8
X_5883_ _5884_/B _5928_/B _5928_/A VDD VSS sg13cmos5l_xnor2_1
XFILLER_61_682 VDD VSS sg13cmos5l_decap_4
X_7622_ _7623_/D _7573_/B _7622_/B VDD VSS sg13cmos5l_nand2b_1
X_4834_ _4901_/B _4834_/A _4834_/B VDD VSS sg13cmos5l_xor2_1
X_7553_ _7613_/C _7553_/A VDD VSS sg13cmos5l_inv_1
X_4765_ _4768_/A _3931_/A _5131_/A _4944_/A VDD VSS sg13cmos5l_a21oi_1
X_6504_ _6836_/B _6504_/A _6504_/B VDD VSS sg13cmos5l_nand2_1
Xrebuffer839 _6842_/B _6471_/A VDD VSS sg13cmos5l_buf_1
X_4696_ _4746_/A _4653_/B _4653_/A _4695_/Y VDD VSS sg13cmos5l_a21oi_1
X_7484_ _7485_/B _7484_/A _7484_/B _7484_/C VDD VSS sg13cmos5l_nand3_1
X_6435_ _6820_/B _6435_/A _6435_/B VDD VSS sg13cmos5l_nand2_1
X_6366_ _6368_/B _6621_/A _6654_/B VDD VSS sg13cmos5l_nand2_1
X_5317_ _5407_/B _5317_/A _5317_/B VDD VSS sg13cmos5l_xor2_1
X_6297_ _6298_/A _6296_/Y _6294_/Y _6317_/C VDD VSS sg13cmos5l_o21ai_1
XFILLER_76_719 VDD VSS sg13cmos5l_fill_2
X_5248_ _5305_/A _5307_/A _5307_/B VDD VSS sg13cmos5l_xor2_1
XFILLER_57_911 VDD VSS sg13cmos5l_fill_2
X_5179_ _5180_/B _5370_/B1 _5685_/A _5310_/B1 _5686_/A VDD VSS sg13cmos5l_a22oi_1
XFILLER_57_933 VDD VSS sg13cmos5l_fill_1
XFILLER_72_914 VDD VSS sg13cmos5l_fill_1
XFILLER_43_104 VDD VSS sg13cmos5l_decap_8
XFILLER_43_115 VDD VSS sg13cmos5l_fill_1
XFILLER_45_35 VDD VSS sg13cmos5l_fill_1
XFILLER_71_468 VDD VSS sg13cmos5l_decap_8
XFILLER_71_446 VDD VSS sg13cmos5l_fill_2
XFILLER_40_822 VDD VSS sg13cmos5l_decap_8
XFILLER_51_192 VDD VSS sg13cmos5l_decap_8
XFILLER_79_557 VDD VSS sg13cmos5l_decap_4
XFILLER_48_933 VDD VSS sg13cmos5l_fill_1
XFILLER_62_424 VDD VSS sg13cmos5l_fill_1
X_4550_ _4606_/A _4550_/A VDD VSS sg13cmos5l_inv_1
X_4481_ _4482_/B _4481_/A VDD VSS sg13cmos5l_inv_1
X_6220_ _6220_/Y _6219_/A _6195_/Y _6219_/Y VDD VSS sg13cmos5l_o21ai_1
X_6151_ _6170_/B _6160_/B _6151_/B VDD VSS sg13cmos5l_xnor2_1
X_5102_ _5107_/A _5102_/A VDD VSS sg13cmos5l_inv_1
X_6082_ _6083_/A _6082_/A1 _6114_/A _6082_/B1 _5683_/X VDD VSS sg13cmos5l_a22oi_1
XFILLER_66_730 VDD VSS sg13cmos5l_fill_1
XFILLER_39_922 VDD VSS sg13cmos5l_decap_8
XFILLER_39_933 VDD VSS sg13cmos5l_fill_1
X_5033_ _5040_/A _5041_/B _5041_/A VDD VSS sg13cmos5l_xor2_1
XFILLER_66_763 VDD VSS sg13cmos5l_decap_8
XFILLER_66_741 VDD VSS sg13cmos5l_decap_8
XFILLER_53_413 VDD VSS sg13cmos5l_fill_2
XFILLER_81_744 VDD VSS sg13cmos5l_decap_8
X_6984_ _6988_/C _7319_/B _7111_/A _6983_/Y VDD VSS sg13cmos5l_o21ai_1
XFILLER_80_276 VDD VSS sg13cmos5l_decap_8
X_5935_ _7697_/D _5935_/A _5935_/B VDD VSS sg13cmos5l_xnor2_1
XFILLER_40_118 VDD VSS sg13cmos5l_decap_8
X_5866_ _5918_/A _5866_/A _5866_/B VDD VSS sg13cmos5l_xnor2_1
XFILLER_61_490 VDD VSS sg13cmos5l_decap_8
X_7605_ _7606_/B _7605_/A _7605_/B _7605_/C VDD VSS sg13cmos5l_nand3_1
X_4817_ _4834_/A _4817_/A _4817_/B VDD VSS sg13cmos5l_xor2_1
X_5797_ _5797_/X _5797_/A _5797_/B VDD VSS sg13cmos5l_and2_1
Xrebuffer658 _7525_/A rebuffer673/X VDD VSS sg13cmos5l_buf_1
Xrebuffer636 rebuffer636/X rebuffer637/X VDD VSS sg13cmos5l_buf_1
X_7536_ _7538_/A _7536_/A _7536_/B VDD VSS sg13cmos5l_nand2_1
Xrebuffer647 _6743_/A rebuffer770/X VDD VSS sg13cmos5l_buf_1
Xrebuffer625 _7125_/A2 rebuffer641/X VDD VSS sg13cmos5l_buf_1
X_4748_ _4749_/B _4511_/X _4429_/X _4986_/B1 _4430_/X VDD VSS sg13cmos5l_a22oi_1
Xrebuffer669 rebuffer669/X rebuffer763/X VDD VSS sg13cmos5l_buf_1
X_7467_ _7597_/A _7464_/A _7467_/B VDD VSS sg13cmos5l_nand2b_1
X_4679_ _4682_/A _4736_/S _4679_/B VDD VSS sg13cmos5l_xnor2_1
X_6418_ _6418_/Y _7313_/A VDD VSS sg13cmos5l_inv_1
X_7398_ _7399_/A _7398_/A VDD VSS sg13cmos5l_buf_1
X_6349_ _6811_/A _7667_/Q _6349_/B VDD VSS sg13cmos5l_xnor2_1
Xinput104 _4044_/B quant_cfg[6] VDD VSS sg13cmos5l_buf_1
XFILLER_48_207 VDD VSS sg13cmos5l_fill_1
XFILLER_76_527 VDD VSS sg13cmos5l_fill_1
Xbank_B_sram.gen_ihp_256x32.u_sram_256x32_500 bank_B_sram.gen_ihp_256x32.u_sram_256x32_500/L_LO
+ VDD VSS sg13cmos5l_tielo
XFILLER_57_774 VDD VSS sg13cmos5l_decap_8
XFILLER_57_785 VDD VSS sg13cmos5l_fill_2
XFILLER_72_744 VDD VSS sg13cmos5l_fill_2
XFILLER_72_733 VDD VSS sg13cmos5l_fill_1
XFILLER_71_232 VDD VSS sg13cmos5l_fill_1
Xbank_B_sram.gen_ihp_256x32.u_sram_256x32_533 bank_B_sram.gen_ihp_256x32.u_sram_256x32_533/L_LO
+ VDD VSS sg13cmos5l_tielo
Xbank_B_sram.gen_ihp_256x32.u_sram_256x32_522 bank_B_sram.gen_ihp_256x32.u_sram_256x32_522/L_LO
+ VDD VSS sg13cmos5l_tielo
Xbank_B_sram.gen_ihp_256x32.u_sram_256x32_511 bank_B_sram.gen_ihp_256x32.u_sram_256x32_511/L_LO
+ VDD VSS sg13cmos5l_tielo
XFILLER_44_424 VDD VSS sg13cmos5l_decap_8
XFILLER_71_254 VDD VSS sg13cmos5l_decap_8
Xbank_B_sram.gen_ihp_256x32.u_sram_256x32_544 bank_B_sram.gen_ihp_256x32.u_sram_256x32_544/L_LO
+ VDD VSS sg13cmos5l_tielo
Xbank_B_sram.gen_ihp_256x32.u_sram_256x32_588 bank_B_sram.gen_ihp_256x32.u_sram_256x32/A_BM[6]
+ VDD VSS sg13cmos5l_tiehi
Xbank_B_sram.gen_ihp_256x32.u_sram_256x32_599 bank_B_sram.gen_ihp_256x32.u_sram_256x32_599/L_HI
+ VDD VSS sg13cmos5l_tiehi
XFILLER_79_310 VDD VSS sg13cmos5l_decap_8
XFILLER_79_398 VDD VSS sg13cmos5l_fill_1
XFILLER_79_387 VDD VSS sg13cmos5l_decap_8
XFILLER_48_752 VDD VSS sg13cmos5l_fill_2
XFILLER_36_914 VDD VSS sg13cmos5l_decap_8
XFILLER_47_273 VDD VSS sg13cmos5l_decap_8
XFILLER_63_711 VDD VSS sg13cmos5l_fill_2
X_3981_ _3981_/X _3981_/A VDD VSS sg13cmos5l_buf_1
XFILLER_62_243 VDD VSS sg13cmos5l_fill_2
X_5720_ _5721_/B _5742_/A _5742_/B VDD VSS sg13cmos5l_xnor2_1
XFILLER_50_449 VDD VSS sg13cmos5l_fill_2
X_5651_ _5722_/A _5592_/B _5592_/A _5650_/Y VDD VSS sg13cmos5l_a21oi_1
X_5582_ _5590_/A _5810_/B _5582_/B VDD VSS sg13cmos5l_xnor2_1
X_4602_ _4662_/A _4602_/A _4602_/B VDD VSS sg13cmos5l_xor2_1
X_4533_ _4534_/B _4581_/A _4581_/B VDD VSS sg13cmos5l_xor2_1
X_7321_ _7323_/A _7289_/A _7318_/Y _7320_/Y VDD VSS sg13cmos5l_o21ai_1
X_7252_ _7252_/Y _7280_/A1 _7247_/Y _7251_/Y VDD VSS sg13cmos5l_o21ai_1
X_6203_ _6203_/Y _6209_/A1 _6201_/Y _6202_/Y VDD VSS sg13cmos5l_a21oi_1
X_4464_ _4480_/A _4483_/A _4464_/B VDD VSS sg13cmos5l_xnor2_1
X_4395_ _4396_/B _4440_/A _4440_/B VDD VSS sg13cmos5l_xor2_1
X_7183_ _7356_/A _7183_/A _7234_/B VDD VSS sg13cmos5l_nand2_1
X_6134_ _7703_/D _6134_/A _6134_/B VDD VSS sg13cmos5l_xor2_1
X_6065_ _6093_/A _6094_/B _6094_/A VDD VSS sg13cmos5l_xor2_1
X_5016_ _5070_/A _5014_/B _5269_/A _5015_/Y VDD VSS sg13cmos5l_a21o_1
XFILLER_38_284 VDD VSS sg13cmos5l_decap_8
XFILLER_53_221 VDD VSS sg13cmos5l_fill_2
XFILLER_42_928 VDD VSS sg13cmos5l_decap_4
XFILLER_54_777 VDD VSS sg13cmos5l_decap_8
XFILLER_54_799 VDD VSS sg13cmos5l_fill_2
X_6967_ _6967_/Y _7221_/B _6981_/A VDD VSS sg13cmos5l_nand2b_1
XFILLER_81_596 VDD VSS sg13cmos5l_decap_8
XFILLER_53_287 VDD VSS sg13cmos5l_decap_8
X_5918_ _5918_/Y _5918_/A _5918_/B VDD VSS sg13cmos5l_nor2_1
X_6898_ _6900_/B _7045_/A _7021_/A _7045_/B VDD VSS sg13cmos5l_nand3_1
X_5849_ _5851_/A _5825_/A _5849_/B VDD VSS sg13cmos5l_nand2b_1
X_7519_ _7520_/B _7519_/A _7519_/B VDD VSS sg13cmos5l_nand2_1
XFILLER_3_19 VDD VSS sg13cmos5l_decap_8
XFILLER_76_302 VDD VSS sg13cmos5l_decap_4
Xclkbuf_4_13_0_clk_i_regs clkload7/A clkbuf_0_clk_i_regs/X VDD VSS sg13cmos5l_buf_8
XFILLER_57_560 VDD VSS sg13cmos5l_fill_2
XFILLER_45_755 VDD VSS sg13cmos5l_fill_1
XFILLER_60_725 VDD VSS sg13cmos5l_fill_1
XFILLER_60_736 VDD VSS sg13cmos5l_decap_8
X_4180_ _4230_/B _4180_/A _4180_/B VDD VSS sg13cmos5l_xor2_1
XFILLER_68_814 VDD VSS sg13cmos5l_fill_2
XFILLER_79_184 VDD VSS sg13cmos5l_decap_8
XFILLER_67_313 VDD VSS sg13cmos5l_fill_2
XFILLER_68_858 VDD VSS sg13cmos5l_decap_8
XFILLER_82_316 VDD VSS sg13cmos5l_fill_1
XFILLER_76_880 VDD VSS sg13cmos5l_fill_1
XFILLER_35_265 VDD VSS sg13cmos5l_decap_4
X_6821_ _6822_/B _6821_/A _6821_/B VDD VSS sg13cmos5l_nand2_1
XFILLER_63_552 VDD VSS sg13cmos5l_fill_2
XFILLER_35_298 VDD VSS sg13cmos5l_decap_4
X_3964_ _3966_/B _3972_/A _4525_/A _3964_/C VDD VSS sg13cmos5l_nand3_1
X_6752_ _7311_/A _7210_/A _6909_/B _7210_/C VDD VSS sg13cmos5l_nand3_1
X_5703_ _5704_/B _5749_/A _5749_/B VDD VSS sg13cmos5l_xor2_1
X_6683_ _6685_/A _6684_/A _6684_/C _7704_/Q VDD VSS sg13cmos5l_a21oi_1
X_5634_ _5635_/B _6058_/B1 _5869_/A2 _6026_/B1 _5869_/B2 VDD VSS sg13cmos5l_a22oi_1
XFILLER_12_28 VDD VSS sg13cmos5l_fill_1
X_7304_ _7310_/A _7304_/A _7304_/B _7559_/A VDD VSS sg13cmos5l_nand3_1
X_5565_ _5565_/Y _5565_/A VDD VSS sg13cmos5l_inv_1
X_5496_ _5499_/A _5556_/S _5496_/B VDD VSS sg13cmos5l_xnor2_1
X_4516_ _4517_/B _4568_/A _4568_/B VDD VSS sg13cmos5l_xor2_1
X_4447_ _4448_/B _4525_/A _4647_/B _4447_/C VDD VSS sg13cmos5l_nor3_1
X_7235_ _7235_/Y _7235_/A _7246_/A VDD VSS sg13cmos5l_nand2_1
X_7166_ _7167_/B _7166_/A _7181_/A VDD VSS sg13cmos5l_nand2_1
X_6117_ _6117_/Y _6117_/A _6117_/B VDD VSS sg13cmos5l_nand2_1
XFILLER_59_847 VDD VSS sg13cmos5l_fill_2
X_4378_ _4379_/B _4262_/X _4876_/A _4205_/X _4877_/A VDD VSS sg13cmos5l_a22oi_1
X_7097_ _7123_/A _7097_/A _7641_/A _7642_/B VDD VSS sg13cmos5l_nand3_1
XFILLER_73_316 VDD VSS sg13cmos5l_fill_2
XFILLER_37_25 VDD VSS sg13cmos5l_decap_8
X_6048_ _6100_/B _6048_/A _6039_/A VDD VSS sg13cmos5l_nor2b_1
XFILLER_46_519 VDD VSS sg13cmos5l_fill_1
XFILLER_73_349 VDD VSS sg13cmos5l_fill_1
XFILLER_66_390 VDD VSS sg13cmos5l_fill_1
XFILLER_42_703 VDD VSS sg13cmos5l_decap_8
XFILLER_42_714 VDD VSS sg13cmos5l_fill_1
XFILLER_41_224 VDD VSS sg13cmos5l_fill_1
XFILLER_53_24 VDD VSS sg13cmos5l_fill_1
XFILLER_53_46 VDD VSS sg13cmos5l_fill_1
XFILLER_53_68 VDD VSS sg13cmos5l_decap_4
XFILLER_77_633 VDD VSS sg13cmos5l_fill_1
XFILLER_77_611 VDD VSS sg13cmos5l_decap_8
XFILLER_77_666 VDD VSS sg13cmos5l_fill_1
XFILLER_65_806 VDD VSS sg13cmos5l_fill_2
Xhold2090 _6207_/A _7728_/Q VDD VSS sg13cmos5l_dlygate4sd3_1
XFILLER_57_390 VDD VSS sg13cmos5l_fill_1
XFILLER_73_861 VDD VSS sg13cmos5l_decap_8
XFILLER_72_382 VDD VSS sg13cmos5l_fill_2
XFILLER_72_371 VDD VSS sg13cmos5l_fill_1
XFILLER_45_596 VDD VSS sg13cmos5l_decap_8
XFILLER_60_522 VDD VSS sg13cmos5l_fill_1
XFILLER_41_780 VDD VSS sg13cmos5l_fill_1
XFILLER_64_4 VDD VSS sg13cmos5l_fill_1
X_5350_ _5364_/B _5412_/A _5350_/B VDD VSS sg13cmos5l_xnor2_1
X_5281_ _5282_/B _5281_/A _5281_/B VDD VSS sg13cmos5l_xor2_1
X_4301_ _4302_/A _6111_/B _6110_/A VDD VSS sg13cmos5l_nor2b_1
X_4232_ _4248_/A _4250_/B _4250_/A VDD VSS sg13cmos5l_xnor2_1
X_7020_ _7020_/Y _7020_/A _7067_/A VDD VSS sg13cmos5l_nand2_1
X_4163_ _4194_/B _4266_/A _4163_/B VDD VSS sg13cmos5l_xnor2_1
X_4094_ _4097_/B _4110_/B _4110_/A VDD VSS sg13cmos5l_xor2_1
XFILLER_67_176 VDD VSS sg13cmos5l_fill_1
XFILLER_56_828 VDD VSS sg13cmos5l_fill_2
XFILLER_82_157 VDD VSS sg13cmos5l_decap_8
XFILLER_64_850 VDD VSS sg13cmos5l_decap_8
XFILLER_63_382 VDD VSS sg13cmos5l_fill_2
XFILLER_64_883 VDD VSS sg13cmos5l_decap_8
X_4996_ _4996_/X _4996_/A VDD VSS sg13cmos5l_buf_1
X_6804_ _6805_/B _6804_/A _6273_/Y VDD VSS sg13cmos5l_nor2b_1
X_3947_ _3948_/B _3947_/A VDD VSS sg13cmos5l_inv_1
X_6735_ _6904_/B _6735_/A _6735_/B VDD VSS sg13cmos5l_xnor2_1
X_6666_ _6676_/A _6681_/A _6665_/Y _6684_/C VDD VSS sg13cmos5l_o21ai_1
X_6597_ _6599_/A _6598_/A _6641_/C _7694_/Q VDD VSS sg13cmos5l_a21oi_1
X_5617_ _7691_/D _5617_/A _5617_/B VDD VSS sg13cmos5l_xnor2_1
X_5548_ _5548_/Y _5548_/A _5479_/A VDD VSS sg13cmos5l_nor2b_1
X_5479_ _5480_/B _5479_/A _5548_/A VDD VSS sg13cmos5l_xnor2_1
X_7218_ _7261_/A _7218_/A VDD VSS sg13cmos5l_buf_1
X_7149_ _7650_/A _7149_/A VDD VSS sg13cmos5l_inv_1
XFILLER_58_132 VDD VSS sg13cmos5l_fill_2
XFILLER_58_154 VDD VSS sg13cmos5l_fill_2
XFILLER_39_390 VDD VSS sg13cmos5l_decap_8
XFILLER_42_522 VDD VSS sg13cmos5l_decap_4
XFILLER_70_886 VDD VSS sg13cmos5l_decap_8
XFILLER_80_88 VDD VSS sg13cmos5l_fill_1
XFILLER_77_474 VDD VSS sg13cmos5l_decap_4
XFILLER_77_452 VDD VSS sg13cmos5l_fill_2
XFILLER_65_625 VDD VSS sg13cmos5l_decap_8
XFILLER_64_168 VDD VSS sg13cmos5l_decap_8
XFILLER_46_872 VDD VSS sg13cmos5l_fill_1
X_4850_ _4974_/B _4850_/A _4843_/A VDD VSS sg13cmos5l_nor2b_1
XFILLER_61_842 VDD VSS sg13cmos5l_fill_2
X_6520_ _6521_/B _6534_/A _6519_/Y _6527_/A VDD VSS sg13cmos5l_o21ai_1
X_4781_ _4782_/B _4781_/A _4781_/B VDD VSS sg13cmos5l_xor2_1
X_6451_ _6454_/B _6451_/A _7677_/Q _6461_/C VDD VSS sg13cmos5l_nand3_1
X_5402_ _5403_/B _5402_/A _5402_/B VDD VSS sg13cmos5l_xor2_1
X_6382_ _6814_/A _7670_/Q _6382_/B VDD VSS sg13cmos5l_xnor2_1
X_5333_ _5336_/A _5517_/A _5698_/A _5519_/B VDD VSS sg13cmos5l_a21oi_1
XFILLER_55_0 VDD VSS sg13cmos5l_fill_2
X_5264_ _5265_/B _5314_/A _5314_/B VDD VSS sg13cmos5l_xor2_1
X_4215_ _4225_/A _4272_/A _4215_/B VDD VSS sg13cmos5l_xnor2_1
X_7003_ _7161_/A _7044_/A _7001_/Y _7002_/Y VDD VSS sg13cmos5l_o21ai_1
X_5195_ _5196_/B _5249_/A _5249_/B VDD VSS sg13cmos5l_xor2_1
X_4146_ _4234_/A _4146_/A _4146_/B VDD VSS sg13cmos5l_nand2_1
XFILLER_68_485 VDD VSS sg13cmos5l_decap_4
X_4077_ _4078_/B _3937_/X _4047_/A _4203_/B _4752_/A VDD VSS sg13cmos5l_a22oi_1
XFILLER_70_116 VDD VSS sg13cmos5l_fill_2
XFILLER_37_872 VDD VSS sg13cmos5l_decap_8
XFILLER_70_138 VDD VSS sg13cmos5l_fill_1
X_4979_ _4980_/B _4979_/A _4979_/B VDD VSS sg13cmos5l_nand2_1
XFILLER_51_385 VDD VSS sg13cmos5l_decap_4
X_6718_ _6990_/C _6896_/A _6927_/B VDD VSS sg13cmos5l_nand2_1
Xclkload3 clkload3/Y clkload3/A VDD VSS sg13cmos5l_inv_1
X_7698_ _7698_/Q clkload3/A _7698_/D fanout383/X VDD VSS sg13cmos5l_dfrbpq_1
X_6649_ _6802_/B _6649_/A VDD VSS sg13cmos5l_buf_4
XFILLER_78_227 VDD VSS sg13cmos5l_decap_8
Xfanout240 _5447_/A _4876_/X VDD VSS sg13cmos5l_buf_1
Xfanout273 _4647_/B _4323_/X VDD VSS sg13cmos5l_buf_1
XFILLER_75_912 VDD VSS sg13cmos5l_fill_1
Xfanout251 _7424_/A _7387_/A VDD VSS sg13cmos5l_buf_1
Xfanout262 _6927_/B _6849_/B VDD VSS sg13cmos5l_buf_1
XFILLER_59_452 VDD VSS sg13cmos5l_decap_8
XFILLER_75_44 VDD VSS sg13cmos5l_decap_8
XFILLER_47_636 VDD VSS sg13cmos5l_decap_8
Xfanout284 _6910_/S _6955_/B VDD VSS sg13cmos5l_buf_1
Xfanout295 _5982_/A _6052_/B VDD VSS sg13cmos5l_buf_1
XFILLER_35_809 VDD VSS sg13cmos5l_decap_8
XFILLER_62_606 VDD VSS sg13cmos5l_decap_4
XFILLER_74_477 VDD VSS sg13cmos5l_decap_8
XFILLER_46_179 VDD VSS sg13cmos5l_fill_2
XFILLER_62_639 VDD VSS sg13cmos5l_decap_4
XFILLER_43_831 VDD VSS sg13cmos5l_decap_8
XFILLER_61_127 VDD VSS sg13cmos5l_fill_1
XFILLER_42_385 VDD VSS sg13cmos5l_decap_8
XFILLER_69_216 VDD VSS sg13cmos5l_decap_8
X_4000_ _4010_/A _4168_/A _4000_/B VDD VSS sg13cmos5l_xnor2_1
XFILLER_66_912 VDD VSS sg13cmos5l_fill_2
XFILLER_77_282 VDD VSS sg13cmos5l_decap_4
XFILLER_38_636 VDD VSS sg13cmos5l_fill_2
XFILLER_37_102 VDD VSS sg13cmos5l_decap_8
XFILLER_65_400 VDD VSS sg13cmos5l_decap_8
XFILLER_37_179 VDD VSS sg13cmos5l_decap_8
XFILLER_53_628 VDD VSS sg13cmos5l_decap_8
X_5951_ _5952_/B _6085_/A _5951_/B VDD VSS sg13cmos5l_xnor2_1
X_4902_ _4963_/A _4902_/A _4902_/B VDD VSS sg13cmos5l_nand2_1
XFILLER_80_469 VDD VSS sg13cmos5l_decap_8
X_5882_ _5928_/B _5882_/A _5891_/A VDD VSS sg13cmos5l_xor2_1
XFILLER_61_650 VDD VSS sg13cmos5l_fill_1
X_7621_ _7622_/B _7621_/A _7621_/B _7621_/C _7621_/D VDD VSS sg13cmos5l_nor4_1
X_4833_ _4834_/B _4867_/A _4833_/B VDD VSS sg13cmos5l_xnor2_1
X_7552_ _7553_/A _7552_/A _7552_/B VDD VSS sg13cmos5l_xor2_1
X_4764_ _5131_/A _4764_/A VDD VSS sg13cmos5l_buf_1
XFILLER_60_193 VDD VSS sg13cmos5l_decap_4
X_6503_ _6505_/B _6503_/A _6506_/B VDD VSS sg13cmos5l_nor2b_1
X_7483_ _7485_/A _7483_/A _7483_/B VDD VSS sg13cmos5l_nand2_2
X_4695_ _4695_/Y _4695_/A _4695_/B VDD VSS sg13cmos5l_nor2_1
X_6434_ _6436_/B _7675_/Q _6434_/B VDD VSS sg13cmos5l_xnor2_1
X_6365_ _6654_/B _6918_/B _6516_/A _6982_/A _6517_/C VDD VSS sg13cmos5l_nor4_1
X_6296_ _6296_/Y _6314_/B VDD VSS sg13cmos5l_inv_2
X_5316_ _5317_/B _5366_/A _5366_/B VDD VSS sg13cmos5l_xor2_1
XFILLER_29_26 VDD VSS sg13cmos5l_fill_2
X_5247_ _5307_/B _5793_/A _5247_/B VDD VSS sg13cmos5l_xnor2_1
XFILLER_75_219 VDD VSS sg13cmos5l_decap_4
X_5178_ _5243_/S _5244_/B1 _5309_/A _5178_/B1 _5683_/A VDD VSS sg13cmos5l_a22oi_1
XFILLER_56_400 VDD VSS sg13cmos5l_fill_2
XFILLER_56_422 VDD VSS sg13cmos5l_fill_2
X_4129_ _4129_/Y _4129_/A _4129_/B VDD VSS sg13cmos5l_nor2_1
XFILLER_56_433 VDD VSS sg13cmos5l_decap_4
XFILLER_71_425 VDD VSS sg13cmos5l_decap_4
XFILLER_71_403 VDD VSS sg13cmos5l_fill_2
XFILLER_43_138 VDD VSS sg13cmos5l_decap_4
XFILLER_40_834 VDD VSS sg13cmos5l_fill_1
XFILLER_40_878 VDD VSS sg13cmos5l_decap_4
XFILLER_75_731 VDD VSS sg13cmos5l_decap_8
XFILLER_47_466 VDD VSS sg13cmos5l_decap_8
XFILLER_62_447 VDD VSS sg13cmos5l_decap_8
XFILLER_35_91 VDD VSS sg13cmos5l_fill_2
XFILLER_51_90 VDD VSS sg13cmos5l_fill_2
X_4480_ _4482_/A _4480_/A VDD VSS sg13cmos5l_inv_1
X_6150_ _6151_/B _6150_/A _6149_/Y VDD VSS sg13cmos5l_nor2b_1
X_5101_ _5102_/A _5101_/A _5101_/B VDD VSS sg13cmos5l_xor2_1
XFILLER_39_901 VDD VSS sg13cmos5l_decap_8
X_6081_ _6108_/B _6061_/B _5788_/A _6081_/S VDD VSS sg13cmos5l_mux2_1
X_5032_ _5041_/A _5042_/B _5042_/A VDD VSS sg13cmos5l_xor2_1
XFILLER_66_797 VDD VSS sg13cmos5l_decap_8
X_6983_ _6983_/Y _6967_/Y _6982_/Y _6416_/A VDD VSS sg13cmos5l_a21oi_1
XFILLER_80_255 VDD VSS sg13cmos5l_decap_8
X_5934_ _5935_/B _5934_/A _5936_/B VDD VSS sg13cmos5l_nand2_1
XFILLER_15_17 VDD VSS sg13cmos5l_decap_8
XFILLER_15_28 VDD VSS sg13cmos5l_fill_1
X_5865_ _5866_/B _5865_/A _5893_/A VDD VSS sg13cmos5l_xnor2_1
X_7604_ _7604_/Y _7477_/B _7478_/B _7464_/B VDD VSS sg13cmos5l_a21oi_1
X_4816_ _4817_/B _4863_/A _4863_/B VDD VSS sg13cmos5l_xor2_1
X_5796_ _5799_/A _5857_/S _5796_/B VDD VSS sg13cmos5l_xnor2_1
X_7535_ _7615_/D _7534_/Y _7543_/A VDD VSS sg13cmos5l_nand2b_1
Xrebuffer637 rebuffer637/X rebuffer638/X VDD VSS sg13cmos5l_buf_1
Xrebuffer648 rebuffer648/X rebuffer649/X VDD VSS sg13cmos5l_buf_1
Xrebuffer626 _7492_/A _7458_/A VDD VSS sg13cmos5l_buf_1
X_4747_ _4776_/A _4710_/B _4710_/A _4746_/Y VDD VSS sg13cmos5l_a21oi_1
Xrebuffer659 _6769_/A1 rebuffer701/X VDD VSS sg13cmos5l_buf_1
X_7466_ _7598_/B _7460_/B _7467_/B VDD VSS sg13cmos5l_nand2b_1
X_4678_ _4679_/B _5245_/A _4678_/B VDD VSS sg13cmos5l_xnor2_1
X_7397_ _7398_/A _7397_/A _7483_/B VDD VSS sg13cmos5l_nor2_1
X_6417_ _7313_/A _6417_/A VDD VSS sg13cmos5l_buf_2
X_6348_ _6349_/B _6368_/A _6347_/Y _6391_/A VDD VSS sg13cmos5l_o21ai_1
Xinput105 _4113_/A quant_cfg[7] VDD VSS sg13cmos5l_buf_1
X_6279_ _6517_/C _6356_/A VDD VSS sg13cmos5l_inv_1
XFILLER_56_230 VDD VSS sg13cmos5l_decap_4
Xbank_B_sram.gen_ihp_256x32.u_sram_256x32_501 bank_B_sram.gen_ihp_256x32.u_sram_256x32_501/L_LO
+ VDD VSS sg13cmos5l_tielo
XFILLER_57_797 VDD VSS sg13cmos5l_decap_8
Xbank_B_sram.gen_ihp_256x32.u_sram_256x32_534 bank_B_sram.gen_ihp_256x32.u_sram_256x32_534/L_LO
+ VDD VSS sg13cmos5l_tielo
Xbank_B_sram.gen_ihp_256x32.u_sram_256x32_512 bank_B_sram.gen_ihp_256x32.u_sram_256x32_512/L_LO
+ VDD VSS sg13cmos5l_tielo
Xbank_B_sram.gen_ihp_256x32.u_sram_256x32_523 bank_B_sram.gen_ihp_256x32.u_sram_256x32_523/L_LO
+ VDD VSS sg13cmos5l_tielo
Xbank_B_sram.gen_ihp_256x32.u_sram_256x32_545 bank_B_sram.gen_ihp_256x32.u_sram_256x32_545/L_LO
+ VDD VSS sg13cmos5l_tielo
XFILLER_44_458 VDD VSS sg13cmos5l_fill_2
XFILLER_44_469 VDD VSS sg13cmos5l_decap_8
XFILLER_71_288 VDD VSS sg13cmos5l_decap_8
Xbank_B_sram.gen_ihp_256x32.u_sram_256x32_589 bank_B_sram.gen_ihp_256x32.u_sram_256x32/A_BM[7]
+ VDD VSS sg13cmos5l_tiehi
XFILLER_40_664 VDD VSS sg13cmos5l_decap_4
XFILLER_79_366 VDD VSS sg13cmos5l_decap_8
XFILLER_67_517 VDD VSS sg13cmos5l_decap_8
XFILLER_35_436 VDD VSS sg13cmos5l_decap_8
X_3980_ _3981_/A _3980_/A VDD VSS sg13cmos5l_buf_1
XFILLER_62_266 VDD VSS sg13cmos5l_decap_8
XFILLER_62_255 VDD VSS sg13cmos5l_decap_8
XFILLER_63_767 VDD VSS sg13cmos5l_decap_4
XFILLER_94_4 VDD VSS sg13cmos5l_decap_8
X_5650_ _5650_/Y _5650_/A _5650_/B VDD VSS sg13cmos5l_nor2_1
X_4601_ _4602_/B _4658_/B _4658_/A VDD VSS sg13cmos5l_xor2_1
X_5581_ _5582_/B _5698_/A _5756_/A2 _5633_/A _5756_/B2 VDD VSS sg13cmos5l_a22oi_1
X_4532_ _4581_/B _5080_/A _4532_/B VDD VSS sg13cmos5l_xnor2_1
X_7320_ _7320_/Y _7320_/A _7343_/A VDD VSS sg13cmos5l_nor2_1
X_7251_ _7251_/Y _7294_/B _7068_/Y _7250_/Y VDD VSS sg13cmos5l_o21ai_1
X_4463_ _4464_/B _4463_/A _4463_/B VDD VSS sg13cmos5l_xor2_1
X_6202_ _6202_/Y _6223_/A _6202_/B VDD VSS sg13cmos5l_nor2_1
X_4394_ _4440_/B _4528_/A _4394_/B VDD VSS sg13cmos5l_xnor2_1
X_7182_ _7234_/B _7182_/A VDD VSS sg13cmos5l_inv_1
X_6133_ _6134_/B _6105_/B _6105_/A _6132_/X VDD VSS sg13cmos5l_a21o_1
X_6064_ _6094_/A _6123_/B _6089_/A VDD VSS sg13cmos5l_xnor2_1
XFILLER_58_539 VDD VSS sg13cmos5l_fill_1
X_5015_ _5015_/Y _5015_/A _5015_/B VDD VSS sg13cmos5l_nor2_1
XFILLER_66_572 VDD VSS sg13cmos5l_decap_4
XFILLER_66_550 VDD VSS sg13cmos5l_decap_8
XFILLER_38_263 VDD VSS sg13cmos5l_decap_8
XFILLER_54_723 VDD VSS sg13cmos5l_decap_8
XFILLER_81_575 VDD VSS sg13cmos5l_decap_8
X_6966_ _7221_/B _6959_/Y _6965_/A _6965_/Y VDD VSS sg13cmos5l_a21oi_1
XFILLER_41_428 VDD VSS sg13cmos5l_decap_8
X_5917_ _5962_/A _5957_/B _5917_/B VDD VSS sg13cmos5l_xor2_1
X_6897_ _7045_/B _6721_/Y _6927_/B VDD VSS sg13cmos5l_nand2b_1
X_5848_ _5889_/A _5848_/A _5848_/B _5848_/C VDD VSS sg13cmos5l_nand3_1
X_5779_ _5780_/B _5840_/B _5840_/A VDD VSS sg13cmos5l_xnor2_1
X_7518_ _7520_/A _7518_/A _7518_/B VDD VSS sg13cmos5l_nand2_1
X_7449_ _7453_/A _7590_/A _7589_/A _7590_/B VDD VSS sg13cmos5l_nand3_1
XFILLER_67_34 VDD VSS sg13cmos5l_decap_4
XFILLER_83_22 VDD VSS sg13cmos5l_decap_8
XFILLER_45_734 VDD VSS sg13cmos5l_decap_8
XFILLER_79_163 VDD VSS sg13cmos5l_decap_8
XFILLER_68_837 VDD VSS sg13cmos5l_decap_8
XFILLER_48_561 VDD VSS sg13cmos5l_fill_2
XFILLER_35_222 VDD VSS sg13cmos5l_fill_1
XFILLER_35_255 VDD VSS sg13cmos5l_fill_2
X_6820_ _6822_/A _6820_/A _6820_/B VDD VSS sg13cmos5l_nand2_1
XFILLER_63_575 VDD VSS sg13cmos5l_fill_1
XFILLER_63_586 VDD VSS sg13cmos5l_fill_1
X_3963_ _3963_/X _3963_/A VDD VSS sg13cmos5l_buf_1
X_6751_ _7210_/C _6751_/A _7162_/B VDD VSS sg13cmos5l_nand2_1
XFILLER_50_236 VDD VSS sg13cmos5l_decap_8
X_5702_ _5749_/B _5872_/A _5702_/B VDD VSS sg13cmos5l_xnor2_1
X_6682_ _6684_/A _6680_/Y _6689_/A VDD VSS sg13cmos5l_nand2b_1
X_5633_ _5633_/X _5633_/A VDD VSS sg13cmos5l_buf_1
X_5564_ _5594_/A _5564_/A _5564_/B VDD VSS sg13cmos5l_xor2_1
X_7303_ _7559_/A _7307_/B _7303_/B VDD VSS sg13cmos5l_xnor2_1
X_4515_ _4568_/B _4578_/A _4515_/B VDD VSS sg13cmos5l_xnor2_1
X_5495_ _5496_/B _5559_/A _5495_/B VDD VSS sg13cmos5l_xnor2_1
X_4446_ _4447_/C _4811_/A VDD VSS sg13cmos5l_inv_1
X_7234_ _7234_/Y _7234_/A _7234_/B VDD VSS sg13cmos5l_nand2_1
X_7165_ _7166_/A _7027_/A _7191_/B _7164_/Y VDD VSS sg13cmos5l_a21oi_1
XFILLER_59_804 VDD VSS sg13cmos5l_decap_4
X_4377_ _4426_/A _4871_/A _4377_/B VDD VSS sg13cmos5l_xnor2_1
X_6116_ _6142_/B _6139_/B _6139_/A VDD VSS sg13cmos5l_xnor2_1
XFILLER_59_815 VDD VSS sg13cmos5l_decap_4
Xrebuffer1199 _4243_/B _4188_/A VDD VSS sg13cmos5l_buf_1
X_7096_ _7642_/B _7096_/A _7715_/Q _7096_/C VDD VSS sg13cmos5l_nand3_1
XFILLER_58_347 VDD VSS sg13cmos5l_fill_2
XFILLER_58_336 VDD VSS sg13cmos5l_decap_4
XFILLER_58_358 VDD VSS sg13cmos5l_decap_8
XFILLER_74_829 VDD VSS sg13cmos5l_fill_2
XFILLER_73_306 VDD VSS sg13cmos5l_decap_4
X_6047_ _7700_/D _6047_/A _6077_/A VDD VSS sg13cmos5l_nor2b_2
XFILLER_39_561 VDD VSS sg13cmos5l_decap_8
XFILLER_39_594 VDD VSS sg13cmos5l_fill_1
XFILLER_54_564 VDD VSS sg13cmos5l_decap_4
XFILLER_81_394 VDD VSS sg13cmos5l_decap_8
X_6949_ _6949_/X _7085_/A _6972_/B VDD VSS sg13cmos5l_and2_1
XFILLER_78_22 VDD VSS sg13cmos5l_fill_2
XFILLER_49_336 VDD VSS sg13cmos5l_decap_4
XFILLER_65_818 VDD VSS sg13cmos5l_fill_1
Xhold2091 _6189_/A _7722_/Q VDD VSS sg13cmos5l_dlygate4sd3_1
XFILLER_58_881 VDD VSS sg13cmos5l_decap_8
XFILLER_64_339 VDD VSS sg13cmos5l_decap_8
XFILLER_45_564 VDD VSS sg13cmos5l_decap_8
XFILLER_60_512 VDD VSS sg13cmos5l_fill_2
XFILLER_57_4 VDD VSS sg13cmos5l_fill_2
X_5280_ _5281_/B _5328_/A _5328_/B VDD VSS sg13cmos5l_xor2_1
X_4300_ _6110_/A _4508_/A _4300_/B VDD VSS sg13cmos5l_nand2_1
X_4231_ _4250_/A _4185_/B _4185_/A _4230_/X VDD VSS sg13cmos5l_a21o_1
XFILLER_68_634 VDD VSS sg13cmos5l_fill_1
X_4162_ _4163_/B _3937_/A _4313_/A _3999_/B _4314_/A VDD VSS sg13cmos5l_a22oi_1
X_4093_ _4110_/A _4093_/A _4093_/B VDD VSS sg13cmos5l_xnor2_1
XFILLER_68_678 VDD VSS sg13cmos5l_decap_8
XFILLER_82_125 VDD VSS sg13cmos5l_decap_4
XFILLER_67_199 VDD VSS sg13cmos5l_fill_2
XFILLER_64_873 VDD VSS sg13cmos5l_fill_1
X_4995_ _5023_/A _4955_/B _4955_/A _4994_/Y VDD VSS sg13cmos5l_a21oi_1
X_6803_ _6803_/Y _7659_/Q _6803_/B VDD VSS sg13cmos5l_xnor2_1
XFILLER_63_394 VDD VSS sg13cmos5l_fill_1
X_3946_ _3947_/A _4128_/A _3946_/B VDD VSS sg13cmos5l_nand2_1
X_6734_ _6735_/B _6734_/A _6734_/B VDD VSS sg13cmos5l_nand2_1
X_6665_ _6665_/Y _6665_/A _6665_/B VDD VSS sg13cmos5l_nor2_1
X_5616_ _5617_/B _5618_/A _5618_/B VDD VSS sg13cmos5l_nand2_1
X_6596_ _6598_/A _6603_/B _6603_/A VDD VSS sg13cmos5l_xnor2_1
X_5547_ _5676_/B _5547_/A VDD VSS sg13cmos5l_buf_1
X_5478_ _5548_/A _5415_/B _5415_/A _5477_/X VDD VSS sg13cmos5l_a21oi_1
X_7217_ _7232_/A _7217_/A _7217_/B _7536_/A VDD VSS sg13cmos5l_nand3_1
X_4429_ _4429_/X _4429_/A VDD VSS sg13cmos5l_buf_1
XFILLER_59_612 VDD VSS sg13cmos5l_fill_2
X_7148_ _7149_/A _7176_/B _7176_/A VDD VSS sg13cmos5l_nor2_1
XFILLER_58_100 VDD VSS sg13cmos5l_decap_4
XFILLER_59_634 VDD VSS sg13cmos5l_decap_8
XFILLER_46_306 VDD VSS sg13cmos5l_fill_1
XFILLER_59_689 VDD VSS sg13cmos5l_fill_2
X_7079_ _7081_/A _6961_/Y _7085_/B _7078_/X VDD VSS sg13cmos5l_a21oi_1
XFILLER_46_328 VDD VSS sg13cmos5l_decap_8
XFILLER_46_339 VDD VSS sg13cmos5l_fill_1
XFILLER_54_361 VDD VSS sg13cmos5l_fill_2
XFILLER_82_692 VDD VSS sg13cmos5l_decap_8
XFILLER_81_191 VDD VSS sg13cmos5l_decap_8
XFILLER_54_383 VDD VSS sg13cmos5l_fill_1
XFILLER_42_578 VDD VSS sg13cmos5l_fill_2
XFILLER_80_34 VDD VSS sg13cmos5l_decap_4
XFILLER_80_67 VDD VSS sg13cmos5l_decap_8
XFILLER_78_910 VDD VSS sg13cmos5l_fill_2
XFILLER_38_818 VDD VSS sg13cmos5l_decap_8
XFILLER_64_125 VDD VSS sg13cmos5l_fill_2
XFILLER_80_607 VDD VSS sg13cmos5l_fill_2
XFILLER_61_821 VDD VSS sg13cmos5l_decap_8
XFILLER_45_394 VDD VSS sg13cmos5l_fill_2
X_4780_ _4781_/B _4780_/A _4780_/B VDD VSS sg13cmos5l_nand2_1
X_6450_ _6452_/A _6451_/A _6461_/C _7677_/Q VDD VSS sg13cmos5l_a21oi_1
X_5401_ _5402_/B _5453_/A _5453_/B VDD VSS sg13cmos5l_xor2_1
X_6381_ _6382_/B _6389_/A _6380_/Y _6391_/A VDD VSS sg13cmos5l_o21ai_1
X_5332_ _5698_/A _5332_/A VDD VSS sg13cmos5l_buf_1
X_5263_ _5314_/B _5446_/A _5263_/B VDD VSS sg13cmos5l_xnor2_1
X_4214_ _4215_/B _4310_/A _3998_/X _4262_/A _4641_/A VDD VSS sg13cmos5l_a22oi_1
X_7002_ _7002_/Y _7002_/A _7044_/A VDD VSS sg13cmos5l_nand2_1
X_5194_ _5249_/B _5446_/A _5194_/B VDD VSS sg13cmos5l_xnor2_1
X_4145_ _4243_/C _4145_/A _4142_/A VDD VSS sg13cmos5l_nor2b_2
XFILLER_71_607 VDD VSS sg13cmos5l_fill_1
X_4076_ _4076_/X _4076_/A VDD VSS sg13cmos5l_buf_1
XFILLER_37_851 VDD VSS sg13cmos5l_decap_8
XFILLER_56_659 VDD VSS sg13cmos5l_decap_4
XFILLER_52_810 VDD VSS sg13cmos5l_fill_1
X_4978_ _4980_/A _4978_/A _4978_/B VDD VSS sg13cmos5l_nand2_1
XFILLER_51_397 VDD VSS sg13cmos5l_fill_2
XFILLER_52_898 VDD VSS sg13cmos5l_decap_4
X_3929_ _3929_/X _3955_/A VDD VSS sg13cmos5l_buf_1
Xclkload4 clkload4/Y clkload4/A VDD VSS sg13cmos5l_inv_1
X_7697_ _7697_/Q clkload1/A _7697_/D fanout384/X VDD VSS sg13cmos5l_dfrbpq_1
X_6717_ _6849_/B _6918_/B VDD VSS sg13cmos5l_buf_2
X_6648_ _6656_/A _6648_/A VDD VSS sg13cmos5l_buf_2
X_6579_ _6587_/B _6579_/A _6579_/B VDD VSS sg13cmos5l_nand2_2
XFILLER_78_206 VDD VSS sg13cmos5l_decap_8
XFILLER_59_46 VDD VSS sg13cmos5l_decap_4
Xfanout230 _7205_/A _7218_/A VDD VSS sg13cmos5l_buf_1
Xfanout241 _5309_/A _4737_/X VDD VSS sg13cmos5l_buf_1
Xfanout252 _7430_/A _7557_/A VDD VSS sg13cmos5l_buf_1
Xfanout263 _6896_/B _6800_/A VDD VSS sg13cmos5l_buf_1
XFILLER_59_442 VDD VSS sg13cmos5l_decap_4
Xfanout274 _4877_/A _4314_/X VDD VSS sg13cmos5l_buf_1
Xfanout296 _5872_/A _5977_/B VDD VSS sg13cmos5l_buf_1
Xfanout285 _6813_/S _6731_/X VDD VSS sg13cmos5l_buf_1
XFILLER_47_659 VDD VSS sg13cmos5l_fill_1
XFILLER_91_22 VDD VSS sg13cmos5l_decap_8
XFILLER_42_320 VDD VSS sg13cmos5l_fill_1
XFILLER_55_692 VDD VSS sg13cmos5l_decap_8
XFILLER_42_364 VDD VSS sg13cmos5l_decap_8
XFILLER_43_898 VDD VSS sg13cmos5l_fill_1
XFILLER_49_90 VDD VSS sg13cmos5l_decap_8
XFILLER_78_784 VDD VSS sg13cmos5l_fill_2
XFILLER_77_261 VDD VSS sg13cmos5l_decap_4
XFILLER_37_158 VDD VSS sg13cmos5l_decap_8
X_5950_ _5951_/B _6058_/B1 _6027_/A2 _6026_/B1 _6027_/B2 VDD VSS sg13cmos5l_a22oi_1
XFILLER_65_478 VDD VSS sg13cmos5l_decap_8
XFILLER_80_448 VDD VSS sg13cmos5l_decap_8
X_4901_ _4902_/B _4835_/A _4901_/B VDD VSS sg13cmos5l_nand2b_1
X_7620_ _7621_/C _7620_/A _7620_/B _7620_/C _7620_/D VDD VSS sg13cmos5l_nand4_1
X_5881_ _5891_/A _5881_/A _5922_/A VDD VSS sg13cmos5l_xnor2_1
X_4832_ _4833_/B _4832_/A _4832_/B VDD VSS sg13cmos5l_xor2_1
XFILLER_60_172 VDD VSS sg13cmos5l_decap_8
X_7551_ _7552_/B _7551_/A _7551_/B VDD VSS sg13cmos5l_nand2_1
X_4763_ _4773_/A _5331_/A _4763_/B VDD VSS sg13cmos5l_xnor2_1
X_6502_ _6506_/B _6502_/A _7683_/Q _6527_/A VDD VSS sg13cmos5l_nand3_1
X_7482_ _7483_/A _7484_/A _7484_/C VDD VSS sg13cmos5l_nand2_1
X_4694_ _4710_/A _4694_/A _4694_/B VDD VSS sg13cmos5l_xor2_1
X_6433_ _6434_/B _6430_/Y _6442_/A _6461_/C VDD VSS sg13cmos5l_o21ai_1
XFILLER_20_18 VDD VSS sg13cmos5l_decap_8
X_6364_ _6815_/B _6364_/A _6364_/B VDD VSS sg13cmos5l_nand2_2
X_6295_ _6314_/B _6295_/A _6295_/B VDD VSS sg13cmos5l_nand2_2
X_5315_ _5366_/B _5265_/B _5265_/A _5314_/X VDD VSS sg13cmos5l_a21oi_1
X_5246_ _5247_/B _5430_/B1 _5685_/A _5370_/B1 _5686_/A VDD VSS sg13cmos5l_a22oi_1
XFILLER_69_773 VDD VSS sg13cmos5l_decap_8
XFILLER_68_250 VDD VSS sg13cmos5l_fill_1
X_5177_ _5185_/A _5122_/B _5048_/A _5177_/S VDD VSS sg13cmos5l_mux2_1
X_4128_ _4129_/B _4128_/A _4172_/B _4128_/C VDD VSS sg13cmos5l_nor3_1
X_4059_ _4079_/A _4172_/B _4262_/A _4058_/Y VDD VSS sg13cmos5l_a21o_1
XFILLER_45_15 VDD VSS sg13cmos5l_fill_1
XFILLER_71_448 VDD VSS sg13cmos5l_fill_1
XFILLER_45_48 VDD VSS sg13cmos5l_fill_2
XFILLER_61_47 VDD VSS sg13cmos5l_fill_2
XFILLER_61_69 VDD VSS sg13cmos5l_fill_1
XFILLER_86_11 VDD VSS sg13cmos5l_decap_8
XFILLER_66_209 VDD VSS sg13cmos5l_decap_4
XFILLER_59_272 VDD VSS sg13cmos5l_decap_4
XFILLER_75_754 VDD VSS sg13cmos5l_fill_1
XFILLER_74_297 VDD VSS sg13cmos5l_fill_1
X_5100_ _5101_/B _5108_/B _5108_/A VDD VSS sg13cmos5l_xor2_1
X_6080_ _6124_/B _6062_/A _6062_/B _6079_/Y VDD VSS sg13cmos5l_a21o_1
X_5031_ _5042_/A _4962_/B _4962_/A _5030_/X VDD VSS sg13cmos5l_a21o_1
XFILLER_65_264 VDD VSS sg13cmos5l_fill_2
XFILLER_80_234 VDD VSS sg13cmos5l_decap_8
X_6982_ _6982_/Y _6982_/A _6982_/B VDD VSS sg13cmos5l_nor2_1
XFILLER_81_779 VDD VSS sg13cmos5l_decap_8
X_5933_ _5936_/B _5933_/A _5933_/B VDD VSS sg13cmos5l_nand2_1
X_5864_ _5893_/A _5808_/B _5808_/A _5863_/X VDD VSS sg13cmos5l_a21oi_1
X_7603_ _7607_/A _7603_/A _7603_/B VDD VSS sg13cmos5l_xnor2_1
X_4815_ _4863_/B _4875_/A _4815_/B VDD VSS sg13cmos5l_xnor2_1
X_7534_ _7534_/Y _7534_/A1 _7531_/B _7245_/B VDD VSS sg13cmos5l_a21oi_1
X_5795_ _5796_/B _6085_/A _5795_/B VDD VSS sg13cmos5l_xnor2_1
Xrebuffer627 _7539_/A1 rebuffer628/X VDD VSS sg13cmos5l_buf_1
Xrebuffer638 rebuffer638/X rebuffer639/X VDD VSS sg13cmos5l_buf_1
X_4746_ _4746_/Y _4746_/A _4709_/B VDD VSS sg13cmos5l_nor2b_1
XFILLER_31_28 VDD VSS sg13cmos5l_fill_1
Xrebuffer616 _7537_/A _7203_/B VDD VSS sg13cmos5l_buf_1
Xrebuffer649 rebuffer649/X rebuffer650/X VDD VSS sg13cmos5l_buf_1
X_7465_ _7469_/A _7465_/A _7597_/B VDD VSS sg13cmos5l_nor2b_1
X_4677_ _4678_/B _4859_/B1 _5118_/A _4799_/B1 _5119_/A VDD VSS sg13cmos5l_a22oi_1
X_6416_ _6417_/A _6416_/A _6697_/A VDD VSS sg13cmos5l_nor2_1
X_7396_ _7503_/A _7430_/A _7410_/A VDD VSS sg13cmos5l_xnor2_1
X_6347_ _6347_/Y _6347_/A _6346_/A VDD VSS sg13cmos5l_nor2b_1
Xinput106 _4114_/B quant_cfg[8] VDD VSS sg13cmos5l_buf_1
X_6278_ _6303_/A _6278_/A VDD VSS sg13cmos5l_buf_8
X_5229_ _5230_/B _5229_/A VDD VSS sg13cmos5l_inv_1
XFILLER_56_220 VDD VSS sg13cmos5l_fill_2
XFILLER_57_743 VDD VSS sg13cmos5l_fill_1
XFILLER_72_702 VDD VSS sg13cmos5l_fill_2
Xbank_B_sram.gen_ihp_256x32.u_sram_256x32_502 bank_B_sram.gen_ihp_256x32.u_sram_256x32_502/L_LO
+ VDD VSS sg13cmos5l_tielo
Xbank_B_sram.gen_ihp_256x32.u_sram_256x32_513 bank_B_sram.gen_ihp_256x32.u_sram_256x32_513/L_LO
+ VDD VSS sg13cmos5l_tielo
Xbank_B_sram.gen_ihp_256x32.u_sram_256x32_524 bank_B_sram.gen_ihp_256x32.u_sram_256x32_524/L_LO
+ VDD VSS sg13cmos5l_tielo
Xbank_B_sram.gen_ihp_256x32.u_sram_256x32_535 bank_B_sram.gen_ihp_256x32.u_sram_256x32_535/L_LO
+ VDD VSS sg13cmos5l_tielo
Xbank_B_sram.gen_ihp_256x32.u_sram_256x32_546 bank_B_sram.gen_ihp_256x32.u_sram_256x32_546/L_LO
+ VDD VSS sg13cmos5l_tielo
XFILLER_72_46 VDD VSS sg13cmos5l_fill_2
XFILLER_97_21 VDD VSS sg13cmos5l_decap_8
XFILLER_79_345 VDD VSS sg13cmos5l_decap_8
XFILLER_11_8 VDD VSS sg13cmos5l_decap_4
XFILLER_47_220 VDD VSS sg13cmos5l_decap_8
XFILLER_48_754 VDD VSS sg13cmos5l_fill_1
XFILLER_48_787 VDD VSS sg13cmos5l_fill_1
XFILLER_63_702 VDD VSS sg13cmos5l_fill_2
XFILLER_63_713 VDD VSS sg13cmos5l_fill_1
XFILLER_35_415 VDD VSS sg13cmos5l_decap_4
XFILLER_62_223 VDD VSS sg13cmos5l_fill_2
XFILLER_35_459 VDD VSS sg13cmos5l_decap_8
XFILLER_50_429 VDD VSS sg13cmos5l_fill_2
X_4600_ _4658_/A _4535_/A _4598_/Y _4599_/Y VDD VSS sg13cmos5l_o21ai_1
X_5580_ _5650_/A _5525_/B _5525_/A _5579_/X VDD VSS sg13cmos5l_a21oi_1
X_4531_ _4532_/B _4750_/A _5081_/A _4688_/A _5082_/A VDD VSS sg13cmos5l_a22oi_1
X_7250_ _7250_/Y _7265_/A _7250_/B VDD VSS sg13cmos5l_nor2_1
X_4462_ _4463_/B _4403_/B _4403_/A _4461_/X VDD VSS sg13cmos5l_a21o_1
X_6201_ _6201_/Y _6201_/A VDD VSS sg13cmos5l_inv_1
X_4393_ _4394_/B _4631_/A _4529_/A _4574_/A _4530_/A VDD VSS sg13cmos5l_a22oi_1
X_7181_ _7182_/A _7181_/A _7483_/B VDD VSS sg13cmos5l_nor2_1
X_6132_ _6132_/X _6132_/A _6132_/B VDD VSS sg13cmos5l_and2_1
X_6063_ _6089_/A _6063_/A _6079_/A VDD VSS sg13cmos5l_xor2_1
X_5014_ _5015_/B _5014_/A _5014_/B _5014_/C VDD VSS sg13cmos5l_nor3_1
XFILLER_39_765 VDD VSS sg13cmos5l_fill_1
XFILLER_39_776 VDD VSS sg13cmos5l_decap_8
XFILLER_38_242 VDD VSS sg13cmos5l_decap_8
XFILLER_26_17 VDD VSS sg13cmos5l_decap_8
XFILLER_26_28 VDD VSS sg13cmos5l_fill_1
XFILLER_81_554 VDD VSS sg13cmos5l_decap_8
X_6965_ _6965_/Y _6965_/A _7142_/A VDD VSS sg13cmos5l_nor2_1
XFILLER_53_267 VDD VSS sg13cmos5l_decap_4
XFILLER_53_278 VDD VSS sg13cmos5l_fill_2
X_5916_ _5917_/B _5916_/A _5916_/B VDD VSS sg13cmos5l_xnor2_1
X_6896_ _7045_/A _6896_/A _6896_/B VDD VSS sg13cmos5l_nand2_2
XFILLER_50_930 VDD VSS sg13cmos5l_decap_4
XFILLER_62_790 VDD VSS sg13cmos5l_decap_8
X_5847_ _7695_/D _5847_/A _5847_/B VDD VSS sg13cmos5l_xnor2_1
X_5778_ _5840_/A _5834_/A _5835_/B VDD VSS sg13cmos5l_xnor2_1
X_7517_ _7619_/B _7516_/Y _7517_/B VDD VSS sg13cmos5l_nand2b_1
X_4729_ _7677_/D _4729_/A _4729_/B VDD VSS sg13cmos5l_xnor2_1
X_7448_ _7590_/B _7443_/B _7456_/A VDD VSS sg13cmos5l_nand2b_1
X_7379_ _7381_/B _7430_/A _7385_/A VDD VSS sg13cmos5l_xnor2_1
XFILLER_76_315 VDD VSS sg13cmos5l_fill_2
XFILLER_67_46 VDD VSS sg13cmos5l_fill_1
XFILLER_45_713 VDD VSS sg13cmos5l_fill_1
XFILLER_57_562 VDD VSS sg13cmos5l_fill_1
XFILLER_57_551 VDD VSS sg13cmos5l_fill_1
XFILLER_44_212 VDD VSS sg13cmos5l_decap_4
XFILLER_72_565 VDD VSS sg13cmos5l_decap_8
Xdelaybuf_1_clk_i clkbuf_0_clk_i/A delaybuf_1_clk_i/A VDD VSS sg13cmos5l_buf_8
XFILLER_79_142 VDD VSS sg13cmos5l_decap_8
XFILLER_68_816 VDD VSS sg13cmos5l_fill_1
XFILLER_76_871 VDD VSS sg13cmos5l_decap_8
XFILLER_75_381 VDD VSS sg13cmos5l_fill_2
XFILLER_75_392 VDD VSS sg13cmos5l_decap_4
XFILLER_35_289 VDD VSS sg13cmos5l_decap_4
X_6750_ _7187_/A _6979_/B VDD VSS sg13cmos5l_buf_2
XFILLER_50_215 VDD VSS sg13cmos5l_fill_2
X_3962_ _3966_/A _4327_/B _3972_/B _4387_/A VDD VSS sg13cmos5l_o21ai_1
X_5701_ _5702_/B _6026_/B1 _5943_/A2 _5985_/B1 _5943_/B2 VDD VSS sg13cmos5l_a22oi_1
X_6681_ _6689_/A _6681_/A _6681_/B _6681_/C VDD VSS sg13cmos5l_nand3_1
X_5632_ _5639_/A _5982_/A _5632_/B VDD VSS sg13cmos5l_xnor2_1
X_5563_ _5564_/B _5563_/A _5619_/A VDD VSS sg13cmos5l_xnor2_1
X_7302_ _7303_/B _6259_/X _7299_/Y _7301_/X VDD VSS sg13cmos5l_o21ai_1
X_4514_ _4515_/B _4375_/X _4313_/X _4310_/X _4314_/X VDD VSS sg13cmos5l_a22oi_1
X_5494_ _5495_/B _5684_/B1 _5685_/A _5622_/B1 _5686_/A VDD VSS sg13cmos5l_a22oi_1
X_4445_ _4448_/A _3972_/A _4811_/A _4944_/A VDD VSS sg13cmos5l_a21oi_1
X_7233_ _7234_/A _7233_/A _7248_/A _7233_/C VDD VSS sg13cmos5l_nand3_1
X_7164_ _7164_/Y _7164_/A _7164_/B VDD VSS sg13cmos5l_nor2_1
X_4376_ _4377_/B _4920_/B1 _4751_/A _4859_/B1 _4076_/X VDD VSS sg13cmos5l_a22oi_1
X_6115_ _6139_/A _5396_/C _4496_/A _6114_/Y VDD VSS sg13cmos5l_o21ai_1
XFILLER_58_304 VDD VSS sg13cmos5l_decap_4
X_7095_ _7641_/A _7122_/B _7716_/Q VDD VSS sg13cmos5l_nand2b_1
XFILLER_59_849 VDD VSS sg13cmos5l_fill_1
X_6046_ _6077_/A _6046_/A _6046_/B _6046_/C VDD VSS sg13cmos5l_nand3_1
XFILLER_73_318 VDD VSS sg13cmos5l_fill_1
XFILLER_54_510 VDD VSS sg13cmos5l_fill_2
XFILLER_54_543 VDD VSS sg13cmos5l_decap_8
XFILLER_81_373 VDD VSS sg13cmos5l_decap_8
XFILLER_42_727 VDD VSS sg13cmos5l_decap_4
XFILLER_41_215 VDD VSS sg13cmos5l_decap_8
XFILLER_42_738 VDD VSS sg13cmos5l_fill_1
XFILLER_54_587 VDD VSS sg13cmos5l_fill_2
XFILLER_53_37 VDD VSS sg13cmos5l_decap_8
X_6948_ _7085_/A _6849_/A _6231_/X _6947_/X VDD VSS sg13cmos5l_a21oi_1
X_6879_ _6879_/Y _6878_/Y _6879_/B VDD VSS sg13cmos5l_nand2b_1
XFILLER_49_315 VDD VSS sg13cmos5l_decap_8
XFILLER_94_11 VDD VSS sg13cmos5l_decap_8
Xhold2092 _6204_/A _7727_/Q VDD VSS sg13cmos5l_dlygate4sd3_1
X_4230_ _4230_/X _4230_/A _4230_/B VDD VSS sg13cmos5l_and2_1
XFILLER_4_20 VDD VSS sg13cmos5l_decap_8
X_4161_ _4314_/A _4161_/A VDD VSS sg13cmos5l_buf_1
XFILLER_67_101 VDD VSS sg13cmos5l_fill_2
X_4092_ _4093_/A _4092_/A _4092_/B VDD VSS sg13cmos5l_xor2_1
XFILLER_56_808 VDD VSS sg13cmos5l_fill_2
XFILLER_82_148 VDD VSS sg13cmos5l_decap_4
XFILLER_36_554 VDD VSS sg13cmos5l_decap_8
XFILLER_36_587 VDD VSS sg13cmos5l_decap_8
X_6802_ _6803_/B _6802_/A _6802_/B VDD VSS sg13cmos5l_nand2_1
X_4994_ _4994_/Y _4994_/A _4954_/B VDD VSS sg13cmos5l_nor2b_1
XFILLER_51_546 VDD VSS sg13cmos5l_fill_2
X_3945_ _5706_/B _4128_/A _3946_/B VDD VSS sg13cmos5l_nor2_1
X_6733_ _6735_/A _6733_/A _6733_/B VDD VSS sg13cmos5l_nand2_1
X_6664_ _6681_/A _6664_/A _6665_/A VDD VSS sg13cmos5l_nor2b_2
X_5615_ _5618_/B _5550_/B _5615_/B VDD VSS sg13cmos5l_nand2b_1
X_6595_ _6603_/B _6671_/A _6595_/B VDD VSS sg13cmos5l_nand2_1
X_5546_ _5615_/B _5781_/A _5546_/B VDD VSS sg13cmos5l_xnor2_1
X_5477_ _5477_/X _5477_/A _5477_/B VDD VSS sg13cmos5l_and2_1
X_7216_ _7536_/A _7201_/A _7292_/A VDD VSS sg13cmos5l_nand2b_1
X_4428_ _4460_/A _4486_/B _4486_/A VDD VSS sg13cmos5l_xor2_1
X_7147_ _7176_/A _7131_/Y _7147_/B VDD VSS sg13cmos5l_nand2b_2
XFILLER_48_48 VDD VSS sg13cmos5l_fill_1
X_4359_ _4408_/A _4467_/B VDD VSS sg13cmos5l_inv_1
XFILLER_59_657 VDD VSS sg13cmos5l_fill_2
XFILLER_59_679 VDD VSS sg13cmos5l_fill_1
X_7078_ _7078_/X _7078_/A _7078_/B VDD VSS sg13cmos5l_and2_1
X_6029_ _6049_/A _6056_/S _6029_/B VDD VSS sg13cmos5l_xnor2_1
XFILLER_39_381 VDD VSS sg13cmos5l_fill_1
XFILLER_55_830 VDD VSS sg13cmos5l_fill_2
XFILLER_55_852 VDD VSS sg13cmos5l_fill_1
XFILLER_82_682 VDD VSS sg13cmos5l_fill_2
XFILLER_55_896 VDD VSS sg13cmos5l_fill_2
XFILLER_81_170 VDD VSS sg13cmos5l_decap_8
XFILLER_54_395 VDD VSS sg13cmos5l_decap_8
XFILLER_42_568 VDD VSS sg13cmos5l_decap_4
XFILLER_89_22 VDD VSS sg13cmos5l_decap_8
XFILLER_78_933 VDD VSS sg13cmos5l_fill_1
XFILLER_49_112 VDD VSS sg13cmos5l_fill_1
XFILLER_38_81 VDD VSS sg13cmos5l_decap_8
XFILLER_37_329 VDD VSS sg13cmos5l_decap_8
XFILLER_49_189 VDD VSS sg13cmos5l_decap_8
XFILLER_49_167 VDD VSS sg13cmos5l_decap_8
XFILLER_46_841 VDD VSS sg13cmos5l_fill_1
XFILLER_73_693 VDD VSS sg13cmos5l_decap_8
XFILLER_60_354 VDD VSS sg13cmos5l_fill_1
XFILLER_61_877 VDD VSS sg13cmos5l_decap_8
XFILLER_60_376 VDD VSS sg13cmos5l_fill_2
X_5400_ _5453_/B _5400_/A _5400_/B VDD VSS sg13cmos5l_xnor2_1
X_6380_ _6380_/Y _6380_/A _6379_/A VDD VSS sg13cmos5l_nor2b_1
X_5331_ _5341_/A _5331_/A _5331_/B VDD VSS sg13cmos5l_xnor2_1
X_7001_ _7001_/Y _7001_/A VDD VSS sg13cmos5l_inv_1
X_5262_ _5263_/B _5684_/B1 _5447_/A _5622_/B1 _5448_/A VDD VSS sg13cmos5l_a22oi_1
X_4213_ _4226_/A _4178_/B _4178_/A _4212_/Y VDD VSS sg13cmos5l_a21oi_1
XFILLER_69_933 VDD VSS sg13cmos5l_fill_1
XFILLER_68_410 VDD VSS sg13cmos5l_decap_8
X_5193_ _5194_/B _5622_/B1 _5447_/A _5000_/X _5448_/A VDD VSS sg13cmos5l_a22oi_1
X_4144_ _7667_/D _4144_/A _4144_/B VDD VSS sg13cmos5l_xor2_1
XFILLER_68_465 VDD VSS sg13cmos5l_fill_2
XFILLER_18_18 VDD VSS sg13cmos5l_decap_8
XFILLER_56_616 VDD VSS sg13cmos5l_decap_8
X_4075_ _4076_/A _4075_/A VDD VSS sg13cmos5l_buf_1
XFILLER_55_148 VDD VSS sg13cmos5l_decap_4
XFILLER_56_649 VDD VSS sg13cmos5l_decap_4
XFILLER_36_340 VDD VSS sg13cmos5l_decap_8
XFILLER_36_351 VDD VSS sg13cmos5l_fill_1
XFILLER_34_28 VDD VSS sg13cmos5l_fill_1
XFILLER_51_343 VDD VSS sg13cmos5l_fill_1
X_6716_ _6896_/A _6716_/A _6716_/B VDD VSS sg13cmos5l_xor2_1
X_4977_ _7681_/D _4977_/A _4977_/B VDD VSS sg13cmos5l_xnor2_1
XFILLER_51_376 VDD VSS sg13cmos5l_fill_1
X_3928_ _3955_/A quant_cfg[0] VDD VSS sg13cmos5l_buf_1
X_7696_ _7696_/Q clkload1/A _7696_/D fanout384/X VDD VSS sg13cmos5l_dfrbpq_1
Xclkload5 clkload5/Y clkload5/A VDD VSS sg13cmos5l_inv_1
X_6647_ _6648_/A _6647_/A _6647_/B _6647_/C VDD VSS sg13cmos5l_and3_1
XFILLER_50_16 VDD VSS sg13cmos5l_decap_8
XFILLER_50_49 VDD VSS sg13cmos5l_fill_2
X_6578_ _6578_/Y _6579_/B _6579_/A VDD VSS sg13cmos5l_nor2_1
X_5529_ _5533_/A _5595_/B _5529_/B VDD VSS sg13cmos5l_xnor2_1
XFILLER_59_25 VDD VSS sg13cmos5l_decap_8
Xfanout231 _7134_/B _7138_/B VDD VSS sg13cmos5l_buf_1
Xfanout220 _5259_/A _4752_/X VDD VSS sg13cmos5l_buf_1
Xfanout253 _7280_/A1 _7158_/X VDD VSS sg13cmos5l_buf_1
Xfanout242 _5199_/A _4640_/X VDD VSS sg13cmos5l_buf_1
Xfanout264 _7008_/B _7038_/B VDD VSS sg13cmos5l_buf_1
Xfanout297 _5870_/A _5897_/B VDD VSS sg13cmos5l_buf_1
Xfanout286 _7021_/A _7034_/B VDD VSS sg13cmos5l_buf_1
XFILLER_59_498 VDD VSS sg13cmos5l_fill_2
Xfanout275 _4876_/A _4313_/X VDD VSS sg13cmos5l_buf_1
XFILLER_74_435 VDD VSS sg13cmos5l_decap_4
XFILLER_42_310 VDD VSS sg13cmos5l_fill_2
XFILLER_43_844 VDD VSS sg13cmos5l_decap_8
XFILLER_61_118 VDD VSS sg13cmos5l_decap_8
XFILLER_70_652 VDD VSS sg13cmos5l_fill_1
XFILLER_43_866 VDD VSS sg13cmos5l_fill_2
XFILLER_77_240 VDD VSS sg13cmos5l_decap_8
XFILLER_77_273 VDD VSS sg13cmos5l_fill_1
XFILLER_38_638 VDD VSS sg13cmos5l_fill_1
XFILLER_37_137 VDD VSS sg13cmos5l_decap_8
XFILLER_65_446 VDD VSS sg13cmos5l_fill_2
XFILLER_81_917 VDD VSS sg13cmos5l_decap_8
XFILLER_80_416 VDD VSS sg13cmos5l_fill_1
XFILLER_52_107 VDD VSS sg13cmos5l_fill_1
XFILLER_80_427 VDD VSS sg13cmos5l_decap_8
XFILLER_45_170 VDD VSS sg13cmos5l_fill_1
X_4900_ _4902_/A _4836_/B _4900_/B VDD VSS sg13cmos5l_nand2b_1
XFILLER_52_129 VDD VSS sg13cmos5l_fill_2
X_5880_ _5922_/A _5923_/B _5923_/A VDD VSS sg13cmos5l_xor2_1
X_4831_ _4832_/B _4882_/A _4882_/B VDD VSS sg13cmos5l_xor2_1
XFILLER_61_663 VDD VSS sg13cmos5l_fill_2
X_7550_ _7552_/A _7550_/A _7550_/B VDD VSS sg13cmos5l_nand2_1
X_4762_ _4763_/B _4872_/A _5199_/A _4811_/A _5200_/A VDD VSS sg13cmos5l_a22oi_1
X_6501_ _6503_/A _6502_/A _6527_/A _7683_/Q VDD VSS sg13cmos5l_a21oi_1
X_7481_ _7484_/C _7603_/B _7603_/A VDD VSS sg13cmos5l_nand2_1
X_4693_ _4694_/B _4742_/A _4742_/B VDD VSS sg13cmos5l_xor2_1
X_6432_ _6442_/A _6441_/B VDD VSS sg13cmos5l_inv_1
X_6363_ _6364_/A _6363_/A _6812_/A VDD VSS sg13cmos5l_nand2_2
X_6294_ _6294_/Y _6295_/B _6295_/A VDD VSS sg13cmos5l_nor2_1
X_5314_ _5314_/X _5314_/A _5314_/B VDD VSS sg13cmos5l_and2_1
X_5245_ _5559_/A _5245_/A VDD VSS sg13cmos5l_buf_1
XFILLER_69_741 VDD VSS sg13cmos5l_decap_8
XFILLER_29_28 VDD VSS sg13cmos5l_fill_1
X_5176_ _5221_/A _5126_/B _5126_/A _5175_/Y VDD VSS sg13cmos5l_a21oi_1
X_4127_ _4128_/C _4433_/A VDD VSS sg13cmos5l_inv_1
XFILLER_68_284 VDD VSS sg13cmos5l_fill_1
XFILLER_56_424 VDD VSS sg13cmos5l_fill_1
XFILLER_56_446 VDD VSS sg13cmos5l_decap_8
XFILLER_56_457 VDD VSS sg13cmos5l_fill_1
X_4058_ _4058_/Y _4058_/A _4058_/B VDD VSS sg13cmos5l_nor2_2
XFILLER_56_479 VDD VSS sg13cmos5l_fill_2
XFILLER_101_22 VDD VSS sg13cmos5l_decap_8
XFILLER_52_652 VDD VSS sg13cmos5l_fill_2
X_7679_ _7679_/Q clkload5/A _7679_/D fanout386/X VDD VSS sg13cmos5l_dfrbpq_1
XFILLER_74_232 VDD VSS sg13cmos5l_fill_2
XFILLER_59_295 VDD VSS sg13cmos5l_decap_8
XFILLER_63_928 VDD VSS sg13cmos5l_decap_4
XFILLER_42_151 VDD VSS sg13cmos5l_fill_2
XFILLER_35_82 VDD VSS sg13cmos5l_fill_1
XFILLER_43_674 VDD VSS sg13cmos5l_decap_8
XFILLER_43_685 VDD VSS sg13cmos5l_fill_1
XFILLER_42_195 VDD VSS sg13cmos5l_fill_2
XFILLER_89_8 VDD VSS sg13cmos5l_decap_8
XFILLER_51_92 VDD VSS sg13cmos5l_fill_1
X_5030_ _5030_/X _5030_/A _5030_/B VDD VSS sg13cmos5l_and2_1
XFILLER_78_582 VDD VSS sg13cmos5l_fill_2
XFILLER_78_593 VDD VSS sg13cmos5l_fill_1
XFILLER_66_777 VDD VSS sg13cmos5l_decap_8
X_6981_ _6982_/B _6981_/A _6981_/B VDD VSS sg13cmos5l_nor2_1
XFILLER_80_213 VDD VSS sg13cmos5l_decap_8
X_5932_ _5935_/A _5936_/C _5971_/B VDD VSS sg13cmos5l_nand2_1
XFILLER_65_298 VDD VSS sg13cmos5l_fill_1
XFILLER_81_758 VDD VSS sg13cmos5l_decap_8
X_5863_ _5863_/X _5863_/A _5863_/B VDD VSS sg13cmos5l_and2_1
X_7602_ _7608_/A _7602_/A _7601_/Y VDD VSS sg13cmos5l_nor2b_2
X_5794_ _5795_/B _5949_/B1 _6027_/A2 _5909_/B1 _6027_/B2 VDD VSS sg13cmos5l_a22oi_1
X_4814_ _4815_/B _4688_/X _4876_/A _4631_/X _4877_/A VDD VSS sg13cmos5l_a22oi_1
X_7533_ _7615_/B _7533_/A _7533_/B VDD VSS sg13cmos5l_xor2_1
X_4745_ _4837_/B _4745_/A _4745_/B VDD VSS sg13cmos5l_xor2_1
Xrebuffer628 rebuffer628/X rebuffer629/X VDD VSS sg13cmos5l_buf_1
Xrebuffer639 rebuffer639/X rebuffer640/X VDD VSS sg13cmos5l_buf_1
Xrebuffer617 _6287_/A _6284_/A VDD VSS sg13cmos5l_buf_1
X_7464_ _7597_/B _7464_/A _7464_/B VDD VSS sg13cmos5l_nand2_1
X_4676_ _4922_/A _4676_/A VDD VSS sg13cmos5l_buf_1
X_6415_ _6435_/B _7674_/Q VDD VSS sg13cmos5l_inv_1
X_7395_ _7410_/A _7404_/A _7289_/B _7394_/Y VDD VSS sg13cmos5l_o21ai_1
X_6346_ _6368_/A _6346_/A _6347_/A VDD VSS sg13cmos5l_nor2b_2
Xinput107 input107/X rst_n VDD VSS sg13cmos5l_buf_1
X_6277_ _6278_/A _6277_/A _6561_/B VDD VSS sg13cmos5l_and2_1
X_5228_ _5230_/A _5228_/A VDD VSS sg13cmos5l_inv_1
XFILLER_57_711 VDD VSS sg13cmos5l_fill_2
X_5159_ _5160_/B _5157_/Y _5090_/B _5158_/Y VDD VSS sg13cmos5l_o21ai_1
XFILLER_57_733 VDD VSS sg13cmos5l_fill_1
XFILLER_45_906 VDD VSS sg13cmos5l_fill_1
XFILLER_56_254 VDD VSS sg13cmos5l_decap_8
Xbank_B_sram.gen_ihp_256x32.u_sram_256x32_503 bank_B_sram.gen_ihp_256x32.u_sram_256x32_503/L_LO
+ VDD VSS sg13cmos5l_tielo
Xbank_B_sram.gen_ihp_256x32.u_sram_256x32_514 bank_B_sram.gen_ihp_256x32.u_sram_256x32_514/L_LO
+ VDD VSS sg13cmos5l_tielo
Xbank_B_sram.gen_ihp_256x32.u_sram_256x32_525 bank_B_sram.gen_ihp_256x32.u_sram_256x32_525/L_LO
+ VDD VSS sg13cmos5l_tielo
XFILLER_56_298 VDD VSS sg13cmos5l_decap_8
Xbank_B_sram.gen_ihp_256x32.u_sram_256x32_536 bank_B_sram.gen_ihp_256x32.u_sram_256x32_536/L_LO
+ VDD VSS sg13cmos5l_tielo
Xbank_B_sram.gen_ihp_256x32.u_sram_256x32_547 bank_B_sram.gen_ihp_256x32.u_sram_256x32_547/L_LO
+ VDD VSS sg13cmos5l_tielo
XFILLER_72_69 VDD VSS sg13cmos5l_decap_4
XFILLER_40_688 VDD VSS sg13cmos5l_decap_4
Xclkbuf_4_4_0_clk_i_regs _7704_/CLK clkbuf_0_clk_i_regs/X VDD VSS sg13cmos5l_buf_8
XFILLER_79_324 VDD VSS sg13cmos5l_decap_8
XFILLER_75_563 VDD VSS sg13cmos5l_decap_8
XFILLER_36_928 VDD VSS sg13cmos5l_decap_4
XFILLER_48_766 VDD VSS sg13cmos5l_fill_2
XFILLER_75_596 VDD VSS sg13cmos5l_fill_2
XFILLER_47_287 VDD VSS sg13cmos5l_decap_8
XFILLER_63_758 VDD VSS sg13cmos5l_fill_1
XFILLER_50_408 VDD VSS sg13cmos5l_fill_2
XFILLER_71_791 VDD VSS sg13cmos5l_decap_8
X_4530_ _4530_/X _4530_/A VDD VSS sg13cmos5l_buf_1
X_4461_ _4461_/X _4461_/A _4461_/B VDD VSS sg13cmos5l_and2_1
X_6200_ _6200_/Y _6209_/A1 _6200_/A2 _6199_/Y VDD VSS sg13cmos5l_a21oi_1
X_7180_ _7183_/A _7178_/X _7248_/A VDD VSS sg13cmos5l_nand2b_1
X_4392_ _4440_/A _4323_/X _4688_/A _4391_/Y VDD VSS sg13cmos5l_a21o_1
X_6131_ _6134_/A _6155_/B _6155_/A VDD VSS sg13cmos5l_xor2_1
X_6062_ _6079_/A _6062_/A _6062_/B VDD VSS sg13cmos5l_xnor2_1
XFILLER_78_390 VDD VSS sg13cmos5l_fill_1
X_5013_ _5014_/C _5382_/A VDD VSS sg13cmos5l_inv_1
XFILLER_38_221 VDD VSS sg13cmos5l_decap_8
XFILLER_38_298 VDD VSS sg13cmos5l_decap_8
XFILLER_54_747 VDD VSS sg13cmos5l_decap_8
XFILLER_81_533 VDD VSS sg13cmos5l_decap_8
X_6964_ _7142_/A _6961_/Y _7087_/B _6964_/S VDD VSS sg13cmos5l_mux2_1
X_6895_ _7635_/B _7611_/B _7611_/A VDD VSS sg13cmos5l_nor2b_2
X_5915_ _5916_/B _5915_/A _5939_/A VDD VSS sg13cmos5l_xnor2_1
X_5846_ _5847_/B _5846_/A _5848_/B VDD VSS sg13cmos5l_nand2_1
X_5777_ _5835_/B _5726_/B _5775_/Y _5776_/Y VDD VSS sg13cmos5l_a21oi_1
X_7516_ _7516_/Y _7516_/A1 _7518_/A _7355_/B VDD VSS sg13cmos5l_a21oi_1
X_4728_ _4729_/B _4726_/X _4728_/B VDD VSS sg13cmos5l_nand2b_1
X_7447_ _7589_/A _7447_/A VDD VSS sg13cmos5l_inv_1
X_4659_ _4660_/B _4602_/B _4602_/A _4658_/X VDD VSS sg13cmos5l_a21o_1
X_7378_ _7385_/A _6418_/Y _7234_/Y _7377_/Y VDD VSS sg13cmos5l_o21ai_1
X_6329_ _6791_/A _6329_/A _6331_/B VDD VSS sg13cmos5l_nor2b_2
XFILLER_69_390 VDD VSS sg13cmos5l_decap_4
XFILLER_57_530 VDD VSS sg13cmos5l_decap_4
XFILLER_72_522 VDD VSS sg13cmos5l_decap_8
XFILLER_60_706 VDD VSS sg13cmos5l_decap_8
XFILLER_72_599 VDD VSS sg13cmos5l_decap_4
XFILLER_60_717 VDD VSS sg13cmos5l_fill_1
XFILLER_40_463 VDD VSS sg13cmos5l_decap_4
XFILLER_79_110 VDD VSS sg13cmos5l_decap_8
XFILLER_79_198 VDD VSS sg13cmos5l_decap_8
XFILLER_36_758 VDD VSS sg13cmos5l_fill_2
XFILLER_35_246 VDD VSS sg13cmos5l_fill_1
XFILLER_63_533 VDD VSS sg13cmos5l_decap_8
X_3961_ _3961_/X _3961_/A VDD VSS sg13cmos5l_buf_1
XFILLER_51_706 VDD VSS sg13cmos5l_fill_2
XFILLER_63_566 VDD VSS sg13cmos5l_decap_8
XFILLER_73_90 VDD VSS sg13cmos5l_decap_8
X_5700_ _5749_/A _5870_/A _5700_/B VDD VSS sg13cmos5l_xnor2_1
X_6680_ _6680_/Y _6681_/A _6681_/C _6681_/B VDD VSS sg13cmos5l_a21oi_1
X_5631_ _5632_/B _5909_/B1 _5941_/A2 _5859_/B1 _5941_/B2 VDD VSS sg13cmos5l_a22oi_1
X_5562_ _5619_/A _5511_/B _5511_/A _5561_/X VDD VSS sg13cmos5l_a21oi_1
X_7301_ _7301_/X _7300_/Y _7158_/X _7059_/Y VDD VSS sg13cmos5l_a21o_1
X_4513_ _4568_/A _4871_/A _4513_/B VDD VSS sg13cmos5l_xnor2_1
X_7232_ _7245_/A _7232_/A _7531_/A _7532_/B VDD VSS sg13cmos5l_nand3_1
X_5493_ _5556_/S _5557_/B1 _5309_/X _5493_/B1 _5116_/X VDD VSS sg13cmos5l_a22oi_1
X_4444_ _4811_/A _4444_/A VDD VSS sg13cmos5l_buf_1
X_4375_ _4375_/X _4375_/A VDD VSS sg13cmos5l_buf_1
X_7163_ _7167_/A _7163_/A _7205_/A _7163_/C VDD VSS sg13cmos5l_nand3_1
X_7094_ _7122_/B _7060_/Y _7094_/B VDD VSS sg13cmos5l_nand2b_2
X_6114_ _6114_/Y _6114_/A _6114_/B VDD VSS sg13cmos5l_nand2_1
XFILLER_59_839 VDD VSS sg13cmos5l_fill_2
X_6045_ _6047_/A _6046_/A _6046_/B _6046_/C VDD VSS sg13cmos5l_a21oi_1
XFILLER_58_349 VDD VSS sg13cmos5l_fill_1
XFILLER_37_39 VDD VSS sg13cmos5l_decap_8
XFILLER_67_894 VDD VSS sg13cmos5l_decap_8
XFILLER_81_352 VDD VSS sg13cmos5l_decap_8
XFILLER_54_599 VDD VSS sg13cmos5l_fill_2
X_6947_ _6947_/X _6947_/A _6947_/B VDD VSS sg13cmos5l_and2_1
X_6878_ _6878_/Y _6878_/A1 _6836_/B _6505_/B VDD VSS sg13cmos5l_a21oi_1
XFILLER_50_761 VDD VSS sg13cmos5l_fill_2
XFILLER_50_783 VDD VSS sg13cmos5l_fill_2
X_5829_ _5830_/A _5829_/A _5829_/B VDD VSS sg13cmos5l_nand2_1
XFILLER_78_24 VDD VSS sg13cmos5l_fill_1
XFILLER_78_57 VDD VSS sg13cmos5l_fill_2
XFILLER_78_35 VDD VSS sg13cmos5l_decap_8
XFILLER_78_79 VDD VSS sg13cmos5l_decap_4
XFILLER_78_68 VDD VSS sg13cmos5l_fill_2
XFILLER_76_135 VDD VSS sg13cmos5l_fill_2
XFILLER_58_850 VDD VSS sg13cmos5l_fill_2
Xhold2093 _6201_/A _7726_/Q VDD VSS sg13cmos5l_dlygate4sd3_1
XFILLER_64_319 VDD VSS sg13cmos5l_fill_1
XFILLER_73_853 VDD VSS sg13cmos5l_decap_4
XFILLER_41_794 VDD VSS sg13cmos5l_fill_1
XFILLER_40_260 VDD VSS sg13cmos5l_decap_8
XFILLER_57_6 VDD VSS sg13cmos5l_fill_1
XFILLER_68_603 VDD VSS sg13cmos5l_decap_4
X_4160_ _4161_/A _4266_/A _5977_/A _4159_/Y VDD VSS sg13cmos5l_o21ai_1
XFILLER_68_647 VDD VSS sg13cmos5l_fill_2
X_4091_ _4092_/B _4120_/A _4120_/B VDD VSS sg13cmos5l_xor2_1
XFILLER_67_146 VDD VSS sg13cmos5l_decap_8
XFILLER_49_861 VDD VSS sg13cmos5l_fill_2
XFILLER_82_105 VDD VSS sg13cmos5l_fill_1
XFILLER_49_883 VDD VSS sg13cmos5l_fill_2
XFILLER_82_138 VDD VSS sg13cmos5l_fill_2
X_6801_ _6801_/Y _6798_/Y _6800_/A _6800_/Y VDD VSS sg13cmos5l_a21oi_1
XFILLER_64_864 VDD VSS sg13cmos5l_decap_8
XFILLER_64_897 VDD VSS sg13cmos5l_fill_2
X_4993_ _5091_/A _4993_/A _4993_/B VDD VSS sg13cmos5l_xor2_1
X_3944_ _7660_/D _3953_/A _3944_/B VDD VSS sg13cmos5l_xor2_1
X_6732_ _6732_/Y _6732_/A _6732_/B VDD VSS sg13cmos5l_xnor2_1
X_6663_ _6665_/A _6671_/A _6663_/B VDD VSS sg13cmos5l_nand2_1
X_5614_ _5617_/A _5618_/C _5674_/B VDD VSS sg13cmos5l_nand2_1
X_6594_ _6600_/A _6594_/A _6594_/B VDD VSS sg13cmos5l_nand2_2
X_5545_ _5546_/B _5545_/A _5544_/Y VDD VSS sg13cmos5l_nor2b_1
X_5476_ _5479_/A _5542_/B _5542_/A VDD VSS sg13cmos5l_xor2_1
X_7215_ _7292_/A _7215_/A VDD VSS sg13cmos5l_inv_1
X_4427_ _4486_/A _4381_/B _4381_/A _4426_/X VDD VSS sg13cmos5l_a21o_1
X_7146_ _7147_/B _7158_/A _7137_/Y _7145_/Y VDD VSS sg13cmos5l_o21ai_1
X_4358_ _4467_/B _4358_/A _4358_/B VDD VSS sg13cmos5l_nor2_1
XFILLER_104_11 VDD VSS sg13cmos5l_decap_8
X_7077_ _7077_/Y _7153_/A _7068_/Y _7076_/Y VDD VSS sg13cmos5l_o21ai_1
X_4289_ _4296_/A _4289_/A _4289_/B VDD VSS sg13cmos5l_xor2_1
XFILLER_74_617 VDD VSS sg13cmos5l_fill_2
XFILLER_46_319 VDD VSS sg13cmos5l_fill_2
X_6028_ _6029_/B _6085_/A _6028_/B VDD VSS sg13cmos5l_xnor2_1
XFILLER_73_149 VDD VSS sg13cmos5l_decap_8
XFILLER_70_812 VDD VSS sg13cmos5l_fill_2
XFILLER_55_875 VDD VSS sg13cmos5l_decap_8
XFILLER_70_867 VDD VSS sg13cmos5l_fill_1
Xdelaybuf_0_clk_i delaybuf_1_clk_i/A clk_i VDD VSS sg13cmos5l_buf_8
XFILLER_78_912 VDD VSS sg13cmos5l_fill_1
XFILLER_49_124 VDD VSS sg13cmos5l_decap_8
XFILLER_49_146 VDD VSS sg13cmos5l_decap_8
XFILLER_38_60 VDD VSS sg13cmos5l_decap_8
XFILLER_37_308 VDD VSS sg13cmos5l_decap_8
XFILLER_65_639 VDD VSS sg13cmos5l_decap_8
XFILLER_64_127 VDD VSS sg13cmos5l_fill_1
XFILLER_54_92 VDD VSS sg13cmos5l_decap_8
XFILLER_61_856 VDD VSS sg13cmos5l_decap_8
X_5330_ _5331_/B _5443_/A _5199_/X _5382_/A _5200_/X VDD VSS sg13cmos5l_a22oi_1
X_5261_ _5314_/A _5442_/A _5261_/B VDD VSS sg13cmos5l_xnor2_1
X_4212_ _4212_/Y _4212_/A _4212_/B VDD VSS sg13cmos5l_nor2_1
X_7000_ _7326_/A _7233_/A _7076_/B _7233_/C VDD VSS sg13cmos5l_nand3_1
X_5192_ _5249_/A _5442_/A _5192_/B VDD VSS sg13cmos5l_xnor2_1
X_4143_ _4143_/Y _4143_/A _4143_/B VDD VSS sg13cmos5l_xnor2_1
X_4074_ _4075_/A _4207_/A _5897_/A _4073_/Y VDD VSS sg13cmos5l_o21ai_1
XFILLER_55_116 VDD VSS sg13cmos5l_decap_8
XFILLER_49_691 VDD VSS sg13cmos5l_decap_8
XFILLER_37_886 VDD VSS sg13cmos5l_decap_8
XFILLER_52_834 VDD VSS sg13cmos5l_decap_8
XFILLER_52_823 VDD VSS sg13cmos5l_decap_8
X_4976_ _4977_/B _4974_/X _4976_/B VDD VSS sg13cmos5l_nand2b_1
X_6715_ _7032_/B _6943_/A VDD VSS sg13cmos5l_buf_2
X_3927_ _3927_/Y _3927_/A VDD VSS sg13cmos5l_inv_1
X_7695_ _7695_/Q clkload1/A _7695_/D fanout391/X VDD VSS sg13cmos5l_dfrbpq_1
X_6646_ _6646_/Y _6647_/A _6647_/C _6647_/B VDD VSS sg13cmos5l_a21oi_1
Xclkbuf_4_9_0_clk_i_regs clkload5/A clkbuf_0_clk_i_regs/X VDD VSS sg13cmos5l_buf_8
Xclkload6 clkload6/Y clkload6/A VDD VSS sg13cmos5l_inv_1
X_6577_ _6579_/B _6671_/A _6577_/B VDD VSS sg13cmos5l_nand2_1
X_5528_ _5529_/B _5528_/A _5596_/B VDD VSS sg13cmos5l_xor2_1
X_5459_ _5460_/C _5755_/A VDD VSS sg13cmos5l_inv_1
Xfanout232 _7108_/S _7112_/B VDD VSS sg13cmos5l_buf_1
XFILLER_59_411 VDD VSS sg13cmos5l_decap_4
Xfanout221 _5258_/A _4751_/X VDD VSS sg13cmos5l_buf_1
Xfanout210 _6317_/C _6328_/C VDD VSS sg13cmos5l_buf_1
Xfanout243 _4947_/B _4585_/X VDD VSS sg13cmos5l_buf_1
Xfanout254 _7327_/A _7349_/A VDD VSS sg13cmos5l_buf_1
Xfanout265 _6160_/B _6175_/B VDD VSS sg13cmos5l_buf_1
X_7129_ _7129_/Y _7153_/A _7129_/B VDD VSS sg13cmos5l_nor2_1
XFILLER_74_414 VDD VSS sg13cmos5l_fill_1
Xfanout276 _4640_/A _3998_/X VDD VSS sg13cmos5l_buf_1
Xfanout298 _5415_/A _5547_/A VDD VSS sg13cmos5l_buf_1
XFILLER_59_466 VDD VSS sg13cmos5l_fill_2
Xfanout287 _7004_/A _7032_/B VDD VSS sg13cmos5l_buf_1
XFILLER_75_58 VDD VSS sg13cmos5l_fill_2
XFILLER_42_344 VDD VSS sg13cmos5l_fill_1
XFILLER_40_83 VDD VSS sg13cmos5l_decap_8
XFILLER_34_8 VDD VSS sg13cmos5l_fill_1
XFILLER_49_70 VDD VSS sg13cmos5l_decap_8
XFILLER_77_296 VDD VSS sg13cmos5l_fill_2
XFILLER_37_116 VDD VSS sg13cmos5l_decap_8
XFILLER_46_683 VDD VSS sg13cmos5l_decap_8
XFILLER_65_91 VDD VSS sg13cmos5l_decap_4
X_4830_ _4882_/B _5080_/A _4830_/B VDD VSS sg13cmos5l_xnor2_1
XFILLER_61_686 VDD VSS sg13cmos5l_fill_1
X_4761_ _5010_/A _4761_/A VDD VSS sg13cmos5l_buf_1
X_7480_ _7484_/A _7480_/A _7480_/B VDD VSS sg13cmos5l_nand2_2
X_6500_ _6502_/A _6508_/B _6508_/A VDD VSS sg13cmos5l_xnor2_1
X_4692_ _4742_/B _4875_/A _4692_/B VDD VSS sg13cmos5l_xnor2_1
X_6431_ _6441_/B _6431_/A _6431_/B VDD VSS sg13cmos5l_nand2_2
X_6362_ _6812_/A _6362_/A _6364_/B VDD VSS sg13cmos5l_nor2b_2
X_5313_ _5366_/A _5368_/A _5368_/B VDD VSS sg13cmos5l_xor2_1
X_6293_ _6295_/A _6293_/A _6293_/B VDD VSS sg13cmos5l_nor2_2
X_5244_ _5307_/A _5310_/B1 _5309_/A _5244_/B1 _5683_/A VDD VSS sg13cmos5l_a22oi_1
X_5175_ _5175_/Y _5175_/A _5125_/A VDD VSS sg13cmos5l_nor2b_1
X_4126_ _4129_/A _3955_/A _4433_/A _3961_/X VDD VSS sg13cmos5l_a21oi_1
XFILLER_68_274 VDD VSS sg13cmos5l_decap_4
XFILLER_57_926 VDD VSS sg13cmos5l_decap_8
X_4057_ _4058_/A _4128_/A _4057_/B _4086_/B VDD VSS sg13cmos5l_nor3_2
XFILLER_72_929 VDD VSS sg13cmos5l_decap_4
XFILLER_37_661 VDD VSS sg13cmos5l_fill_1
XFILLER_36_193 VDD VSS sg13cmos5l_decap_8
XFILLER_52_642 VDD VSS sg13cmos5l_fill_2
XFILLER_52_697 VDD VSS sg13cmos5l_fill_2
XFILLER_51_174 VDD VSS sg13cmos5l_fill_2
X_4959_ _4959_/Y _4898_/A _4959_/B VDD VSS sg13cmos5l_nand2b_1
X_7678_ _7678_/Q clkload5/A _7678_/D fanout386/X VDD VSS sg13cmos5l_dfrbpq_1
X_6629_ _6635_/A _6629_/A _6629_/B VDD VSS sg13cmos5l_nand2_2
XFILLER_48_904 VDD VSS sg13cmos5l_fill_2
XFILLER_75_712 VDD VSS sg13cmos5l_fill_1
XFILLER_75_701 VDD VSS sg13cmos5l_fill_2
XFILLER_48_915 VDD VSS sg13cmos5l_decap_4
XFILLER_74_211 VDD VSS sg13cmos5l_decap_8
XFILLER_63_907 VDD VSS sg13cmos5l_fill_1
XFILLER_74_288 VDD VSS sg13cmos5l_fill_2
XFILLER_43_642 VDD VSS sg13cmos5l_decap_8
XFILLER_70_472 VDD VSS sg13cmos5l_decap_4
XFILLER_70_494 VDD VSS sg13cmos5l_fill_2
XFILLER_70_483 VDD VSS sg13cmos5l_fill_2
XFILLER_42_174 VDD VSS sg13cmos5l_decap_4
XFILLER_51_60 VDD VSS sg13cmos5l_decap_8
XFILLER_39_915 VDD VSS sg13cmos5l_decap_8
XFILLER_54_929 VDD VSS sg13cmos5l_decap_4
X_6980_ _6981_/B _6908_/B _6973_/Y _6979_/Y VDD VSS sg13cmos5l_o21ai_1
X_5931_ _5971_/B _5930_/B _5931_/B VDD VSS sg13cmos5l_nand2b_1
XFILLER_53_428 VDD VSS sg13cmos5l_fill_1
XFILLER_80_269 VDD VSS sg13cmos5l_decap_8
X_5862_ _5865_/A _5908_/S _5862_/B VDD VSS sg13cmos5l_xnor2_1
X_7601_ _7601_/Y _7629_/A _7601_/B VDD VSS sg13cmos5l_nor2_1
X_5793_ _6110_/B _5793_/A VDD VSS sg13cmos5l_buf_1
XFILLER_61_483 VDD VSS sg13cmos5l_decap_8
X_4813_ _4863_/A _4871_/A _4813_/B VDD VSS sg13cmos5l_xnor2_1
X_7532_ _7533_/B _7540_/B _7532_/B VDD VSS sg13cmos5l_nand2_1
X_4744_ _4745_/B _4744_/A _4796_/A VDD VSS sg13cmos5l_xnor2_1
Xrebuffer618 _7543_/A rebuffer660/X VDD VSS sg13cmos5l_buf_1
Xrebuffer629 rebuffer629/X rebuffer630/X VDD VSS sg13cmos5l_buf_1
X_7463_ _7464_/A _7472_/A1 _7253_/Y _7472_/B1 VDD VSS sg13cmos5l_o21ai_1
X_4675_ _4736_/S _4738_/B1 _4737_/A _4675_/B1 _5116_/A VDD VSS sg13cmos5l_a22oi_1
X_6414_ _6821_/A _6823_/B _6823_/A VDD VSS sg13cmos5l_nand2_2
X_7394_ _7394_/Y _7284_/A _7394_/A2 _7377_/B VDD VSS sg13cmos5l_a21oi_1
X_6345_ _6347_/A _6621_/A _6638_/B VDD VSS sg13cmos5l_nand2_1
X_6276_ _6576_/A _6276_/A VDD VSS sg13cmos5l_buf_4
X_5227_ _5232_/B _5227_/A _5227_/B VDD VSS sg13cmos5l_xnor2_1
XFILLER_69_583 VDD VSS sg13cmos5l_fill_1
XFILLER_56_38 VDD VSS sg13cmos5l_decap_4
X_5158_ _5158_/Y _5089_/A _5158_/B VDD VSS sg13cmos5l_nand2b_1
XFILLER_57_723 VDD VSS sg13cmos5l_fill_1
X_4109_ _4145_/A _4109_/A _4109_/B VDD VSS sg13cmos5l_nand2_2
XFILLER_72_704 VDD VSS sg13cmos5l_fill_1
XFILLER_45_929 VDD VSS sg13cmos5l_decap_4
X_5089_ _5090_/B _5089_/A _5158_/B VDD VSS sg13cmos5l_xor2_1
XFILLER_57_756 VDD VSS sg13cmos5l_fill_1
XFILLER_57_767 VDD VSS sg13cmos5l_decap_8
XFILLER_112_11 VDD VSS sg13cmos5l_decap_8
XFILLER_72_726 VDD VSS sg13cmos5l_decap_8
XFILLER_71_214 VDD VSS sg13cmos5l_fill_2
Xbank_B_sram.gen_ihp_256x32.u_sram_256x32_504 bank_B_sram.gen_ihp_256x32.u_sram_256x32_504/L_LO
+ VDD VSS sg13cmos5l_tielo
Xbank_B_sram.gen_ihp_256x32.u_sram_256x32_515 bank_B_sram.gen_ihp_256x32.u_sram_256x32_515/L_LO
+ VDD VSS sg13cmos5l_tielo
Xbank_B_sram.gen_ihp_256x32.u_sram_256x32_537 bank_B_sram.gen_ihp_256x32.u_sram_256x32_537/L_LO
+ VDD VSS sg13cmos5l_tielo
Xbank_B_sram.gen_ihp_256x32.u_sram_256x32_526 bank_B_sram.gen_ihp_256x32.u_sram_256x32_526/L_LO
+ VDD VSS sg13cmos5l_tielo
XFILLER_80_792 VDD VSS sg13cmos5l_fill_2
XFILLER_79_303 VDD VSS sg13cmos5l_decap_8
XFILLER_47_211 VDD VSS sg13cmos5l_decap_4
XFILLER_36_907 VDD VSS sg13cmos5l_decap_8
XFILLER_47_255 VDD VSS sg13cmos5l_decap_4
XFILLER_35_406 VDD VSS sg13cmos5l_decap_4
XFILLER_70_291 VDD VSS sg13cmos5l_decap_8
X_4460_ _4463_/A _4460_/A _4460_/B VDD VSS sg13cmos5l_xor2_1
X_4391_ _4391_/Y _4391_/A _4391_/B VDD VSS sg13cmos5l_nor2_1
X_6130_ _6155_/A _6160_/B _6099_/B _6129_/Y VDD VSS sg13cmos5l_o21ai_1
X_6061_ _6062_/B _6081_/S _6061_/B VDD VSS sg13cmos5l_xnor2_1
X_5012_ _5015_/A _3931_/A _5382_/A _5519_/B VDD VSS sg13cmos5l_a21oi_1
XFILLER_38_200 VDD VSS sg13cmos5l_decap_8
XFILLER_81_512 VDD VSS sg13cmos5l_decap_8
XFILLER_38_277 VDD VSS sg13cmos5l_decap_8
X_6963_ _7087_/B _6826_/Y _6711_/X _6962_/X VDD VSS sg13cmos5l_a21oi_1
XFILLER_81_589 VDD VSS sg13cmos5l_decap_8
X_6894_ _7611_/B _6894_/A _6894_/B VDD VSS sg13cmos5l_nand2_2
X_5914_ _5939_/A _5874_/B _5874_/A _5913_/X VDD VSS sg13cmos5l_a21oi_1
X_5845_ _5848_/B _5845_/A _5845_/B VDD VSS sg13cmos5l_nand2_1
X_5776_ _5776_/Y _5776_/A _5776_/B VDD VSS sg13cmos5l_nor2_1
X_7515_ _7619_/A _7515_/A _7515_/B VDD VSS sg13cmos5l_xor2_1
X_4727_ _4728_/B _4727_/A _4727_/B VDD VSS sg13cmos5l_nand2_2
X_7446_ _7447_/A _7464_/B _7452_/A VDD VSS sg13cmos5l_nor2_1
X_4658_ _4658_/X _4658_/A _4658_/B VDD VSS sg13cmos5l_and2_1
Xinput90 _7709_/D quant_cfg[18] VDD VSS sg13cmos5l_buf_1
XFILLER_101_8 VDD VSS sg13cmos5l_decap_8
XFILLER_107_22 VDD VSS sg13cmos5l_decap_8
X_4589_ _4590_/B _5014_/A _4647_/B _4589_/C VDD VSS sg13cmos5l_nor3_1
X_7377_ _7377_/Y _7377_/A _7377_/B VDD VSS sg13cmos5l_nor2_1
X_6328_ _6331_/B _6328_/A _7665_/Q _6328_/C VDD VSS sg13cmos5l_nand3_1
XFILLER_77_829 VDD VSS sg13cmos5l_decap_4
XFILLER_76_306 VDD VSS sg13cmos5l_fill_1
X_6259_ _6259_/X _6259_/A VDD VSS sg13cmos5l_buf_2
XFILLER_68_807 VDD VSS sg13cmos5l_decap_8
XFILLER_79_177 VDD VSS sg13cmos5l_decap_8
XFILLER_67_328 VDD VSS sg13cmos5l_decap_4
X_3960_ _3961_/A _4128_/A VDD VSS sg13cmos5l_inv_1
XFILLER_35_269 VDD VSS sg13cmos5l_fill_1
XFILLER_92_4 VDD VSS sg13cmos5l_decap_8
X_5630_ _6052_/B _5630_/A VDD VSS sg13cmos5l_buf_1
X_5561_ _5561_/X _5561_/A _5561_/B VDD VSS sg13cmos5l_and2_1
X_4512_ _4513_/B _5050_/B1 _4751_/A _4986_/B1 _4752_/A VDD VSS sg13cmos5l_a22oi_1
X_7300_ _7300_/Y _7126_/Y _7294_/B _7182_/A VDD VSS sg13cmos5l_a21oi_1
X_5492_ _5500_/A _5433_/B _5302_/A _5492_/S VDD VSS sg13cmos5l_mux2_1
X_7231_ _7532_/B _7214_/B _7307_/B VDD VSS sg13cmos5l_nand2b_1
X_4443_ _4453_/A _4761_/A _4443_/B VDD VSS sg13cmos5l_xnor2_1
X_7162_ _7163_/C _7162_/A _7162_/B _7162_/C VDD VSS sg13cmos5l_nand3_1
X_4374_ _4381_/A _4432_/A _4374_/B VDD VSS sg13cmos5l_xnor2_1
X_7093_ _7094_/B _7077_/Y _7313_/A _7092_/Y VDD VSS sg13cmos5l_a21oi_1
X_6113_ _6139_/B _6138_/A VDD VSS sg13cmos5l_inv_1
X_6044_ _6046_/C _6076_/B _6076_/A VDD VSS sg13cmos5l_xor2_1
XFILLER_37_18 VDD VSS sg13cmos5l_decap_8
XFILLER_81_331 VDD VSS sg13cmos5l_decap_8
X_6946_ _7065_/A _6843_/A _6939_/A _6945_/X VDD VSS sg13cmos5l_a21oi_1
XFILLER_50_740 VDD VSS sg13cmos5l_decap_8
X_6877_ _6877_/Y _6877_/A _6877_/B VDD VSS sg13cmos5l_nand2_1
X_5828_ _5829_/B _5773_/A _5828_/B VDD VSS sg13cmos5l_nand2b_1
X_5759_ _5768_/A _5817_/B _5817_/A VDD VSS sg13cmos5l_xor2_1
X_7429_ _7498_/B _7570_/B _7429_/B VDD VSS sg13cmos5l_xnor2_1
XFILLER_76_103 VDD VSS sg13cmos5l_decap_8
Xhold2094 _7611_/A _7713_/Q VDD VSS sg13cmos5l_dlygate4sd3_1
XFILLER_57_350 VDD VSS sg13cmos5l_decap_4
XFILLER_58_895 VDD VSS sg13cmos5l_decap_4
XFILLER_72_320 VDD VSS sg13cmos5l_decap_4
XFILLER_57_383 VDD VSS sg13cmos5l_decap_8
XFILLER_72_353 VDD VSS sg13cmos5l_fill_2
XFILLER_73_898 VDD VSS sg13cmos5l_decap_8
XFILLER_41_773 VDD VSS sg13cmos5l_decap_8
XFILLER_43_83 VDD VSS sg13cmos5l_fill_2
XFILLER_40_272 VDD VSS sg13cmos5l_decap_4
XFILLER_40_294 VDD VSS sg13cmos5l_decap_8
XFILLER_68_626 VDD VSS sg13cmos5l_fill_2
XFILLER_67_103 VDD VSS sg13cmos5l_fill_1
X_4090_ _4120_/B _4090_/A _4090_/B VDD VSS sg13cmos5l_xnor2_1
XFILLER_36_501 VDD VSS sg13cmos5l_decap_8
XFILLER_64_843 VDD VSS sg13cmos5l_decap_8
XFILLER_63_364 VDD VSS sg13cmos5l_fill_2
X_6800_ _6800_/Y _6800_/A _6800_/B VDD VSS sg13cmos5l_nor2_1
X_4992_ _4993_/B _4992_/A _5046_/A VDD VSS sg13cmos5l_xnor2_1
XFILLER_63_375 VDD VSS sg13cmos5l_decap_8
X_3943_ _3944_/B _4203_/B _5206_/A VDD VSS sg13cmos5l_nand2_1
X_6731_ _6731_/X _6939_/A VDD VSS sg13cmos5l_buf_1
XFILLER_51_548 VDD VSS sg13cmos5l_fill_1
X_6662_ _6676_/B _7702_/Q VDD VSS sg13cmos5l_inv_1
X_5613_ _5674_/B _5612_/B _5613_/B VDD VSS sg13cmos5l_nand2b_1
X_6593_ _6594_/B _6591_/B _7693_/Q VDD VSS sg13cmos5l_nand2b_1
X_5544_ _5544_/Y _5544_/A _5544_/B _5544_/C VDD VSS sg13cmos5l_nand3_1
X_5475_ _5542_/A _5536_/A _5475_/B VDD VSS sg13cmos5l_xnor2_1
X_7214_ _7217_/B _7307_/B _7214_/B VDD VSS sg13cmos5l_xnor2_1
X_4426_ _4426_/X _4426_/A _4426_/B VDD VSS sg13cmos5l_and2_1
X_7145_ _7145_/Y _7141_/Y _7144_/Y _6416_/A VDD VSS sg13cmos5l_a21oi_1
XFILLER_48_28 VDD VSS sg13cmos5l_fill_1
X_4357_ _4358_/B _4357_/A VDD VSS sg13cmos5l_inv_1
XFILLER_58_125 VDD VSS sg13cmos5l_decap_8
XFILLER_59_648 VDD VSS sg13cmos5l_fill_2
XFILLER_59_659 VDD VSS sg13cmos5l_fill_1
X_4288_ _4289_/B _4297_/B _4297_/A VDD VSS sg13cmos5l_xor2_1
X_7076_ _7076_/Y _7246_/B _7076_/B VDD VSS sg13cmos5l_nand2_1
X_6027_ _6028_/B _6082_/A1 _6027_/A2 _6082_/B1 _6027_/B2 VDD VSS sg13cmos5l_a22oi_1
XFILLER_55_843 VDD VSS sg13cmos5l_fill_1
XFILLER_82_673 VDD VSS sg13cmos5l_fill_2
XFILLER_64_49 VDD VSS sg13cmos5l_fill_2
XFILLER_66_191 VDD VSS sg13cmos5l_decap_4
XFILLER_42_515 VDD VSS sg13cmos5l_decap_8
XFILLER_42_526 VDD VSS sg13cmos5l_fill_2
XFILLER_55_898 VDD VSS sg13cmos5l_fill_1
X_6929_ _6929_/Y _6929_/A _6939_/A VDD VSS sg13cmos5l_nand2_1
XFILLER_50_570 VDD VSS sg13cmos5l_fill_1
XFILLER_77_489 VDD VSS sg13cmos5l_fill_1
XFILLER_77_478 VDD VSS sg13cmos5l_fill_1
XFILLER_77_467 VDD VSS sg13cmos5l_decap_8
XFILLER_65_607 VDD VSS sg13cmos5l_fill_2
XFILLER_65_618 VDD VSS sg13cmos5l_decap_8
XFILLER_58_692 VDD VSS sg13cmos5l_fill_2
XFILLER_46_865 VDD VSS sg13cmos5l_decap_8
XFILLER_61_835 VDD VSS sg13cmos5l_decap_8
XFILLER_54_71 VDD VSS sg13cmos5l_decap_8
X_5260_ _5261_/B _5792_/B1 _5869_/A2 _5745_/B1 _5869_/B2 VDD VSS sg13cmos5l_a22oi_1
X_4211_ _4286_/B _4255_/A _4211_/B VDD VSS sg13cmos5l_xnor2_1
X_5191_ _5192_/B _5745_/B1 _5258_/A _5684_/B1 _5259_/A VDD VSS sg13cmos5l_a22oi_1
X_4142_ _4143_/A _4142_/A _4145_/A VDD VSS sg13cmos5l_xor2_1
XFILLER_68_445 VDD VSS sg13cmos5l_fill_2
X_4073_ _4073_/Y _5898_/B _4207_/A VDD VSS sg13cmos5l_nand2_1
XFILLER_56_607 VDD VSS sg13cmos5l_decap_4
XFILLER_37_865 VDD VSS sg13cmos5l_decap_8
XFILLER_63_161 VDD VSS sg13cmos5l_decap_8
XFILLER_64_673 VDD VSS sg13cmos5l_fill_2
X_4975_ _4975_/Y _4975_/A _4975_/B VDD VSS sg13cmos5l_nand2_2
X_6714_ _6964_/S _6768_/A VDD VSS sg13cmos5l_buf_4
X_7694_ _7694_/Q clkload4/A _7694_/D fanout383/X VDD VSS sg13cmos5l_dfrbpq_1
Xclkload7 clkload7/Y clkload7/A VDD VSS sg13cmos5l_inv_1
X_6645_ _6647_/B _6671_/A _6645_/B VDD VSS sg13cmos5l_nand2_1
X_6576_ _6688_/A _6576_/A VDD VSS sg13cmos5l_buf_1
X_5527_ _5596_/B _5566_/B _5566_/A VDD VSS sg13cmos5l_xor2_1
X_5458_ _5461_/A _5517_/A _5755_/A _5519_/B VDD VSS sg13cmos5l_a21oi_1
X_5389_ _5389_/Y _5389_/A _5389_/B VDD VSS sg13cmos5l_nor2_1
Xfanout222 _5200_/A _4641_/X VDD VSS sg13cmos5l_buf_1
Xfanout200 _5756_/B2 _5200_/X VDD VSS sg13cmos5l_buf_1
Xfanout211 _6027_/A2 _5685_/X VDD VSS sg13cmos5l_buf_1
X_4409_ _4476_/B _4471_/A _4470_/A VDD VSS sg13cmos5l_xnor2_1
XFILLER_115_22 VDD VSS sg13cmos5l_decap_8
Xfanout233 _7085_/B _7087_/A VDD VSS sg13cmos5l_buf_1
X_7128_ _7129_/B _7134_/B _6922_/A _7127_/Y VDD VSS sg13cmos5l_o21ai_1
Xfanout244 _5119_/A _4564_/X VDD VSS sg13cmos5l_buf_1
Xfanout255 _7153_/A _7051_/X VDD VSS sg13cmos5l_buf_1
Xfanout277 _7374_/B _7347_/B VDD VSS sg13cmos5l_buf_1
X_7059_ _7059_/Y _7059_/A VDD VSS sg13cmos5l_inv_1
Xfanout299 _5331_/A _5010_/A VDD VSS sg13cmos5l_buf_1
Xfanout266 _6111_/A _5811_/A VDD VSS sg13cmos5l_buf_1
XFILLER_47_629 VDD VSS sg13cmos5l_fill_2
Xfanout288 _6957_/S _6711_/X VDD VSS sg13cmos5l_buf_1
XFILLER_46_139 VDD VSS sg13cmos5l_fill_1
XFILLER_39_191 VDD VSS sg13cmos5l_decap_4
XFILLER_82_481 VDD VSS sg13cmos5l_fill_2
XFILLER_43_868 VDD VSS sg13cmos5l_fill_1
XFILLER_40_62 VDD VSS sg13cmos5l_decap_8
XFILLER_69_209 VDD VSS sg13cmos5l_decap_8
XFILLER_78_732 VDD VSS sg13cmos5l_decap_8
XFILLER_27_8 VDD VSS sg13cmos5l_decap_8
XFILLER_1_12 VDD VSS sg13cmos5l_decap_8
XFILLER_77_286 VDD VSS sg13cmos5l_fill_2
XFILLER_61_621 VDD VSS sg13cmos5l_fill_1
XFILLER_60_142 VDD VSS sg13cmos5l_decap_8
XFILLER_61_665 VDD VSS sg13cmos5l_fill_1
X_4760_ _4807_/A _4708_/B _4708_/A _4759_/Y VDD VSS sg13cmos5l_a21oi_1
XFILLER_60_186 VDD VSS sg13cmos5l_decap_8
XFILLER_60_197 VDD VSS sg13cmos5l_fill_2
X_4691_ _4692_/B _4574_/X _4876_/A _4511_/X _4877_/A VDD VSS sg13cmos5l_a22oi_1
X_6430_ _6430_/Y _6431_/B _6431_/A VDD VSS sg13cmos5l_nor2_1
X_6361_ _6364_/B _6361_/A _7668_/Q _6391_/A VDD VSS sg13cmos5l_nand3_1
X_5312_ _5368_/B _5793_/A _5312_/B VDD VSS sg13cmos5l_xnor2_1
X_6292_ _6295_/B _6343_/A _6595_/B VDD VSS sg13cmos5l_nand2_2
XFILLER_69_710 VDD VSS sg13cmos5l_fill_1
X_5243_ _5252_/A _5181_/B _5048_/A _5243_/S VDD VSS sg13cmos5l_mux2_1
XFILLER_29_19 VDD VSS sg13cmos5l_decap_8
X_5174_ _5295_/A _5165_/B _5172_/Y _5173_/X VDD VSS sg13cmos5l_a21oi_1
X_4125_ _4433_/A _4125_/A VDD VSS sg13cmos5l_buf_2
XFILLER_69_787 VDD VSS sg13cmos5l_decap_4
XFILLER_68_264 VDD VSS sg13cmos5l_decap_4
XFILLER_56_437 VDD VSS sg13cmos5l_fill_1
X_4056_ _4057_/B _4310_/A VDD VSS sg13cmos5l_inv_2
XFILLER_71_429 VDD VSS sg13cmos5l_fill_1
XFILLER_71_418 VDD VSS sg13cmos5l_fill_2
XFILLER_36_172 VDD VSS sg13cmos5l_decap_8
XFILLER_40_805 VDD VSS sg13cmos5l_decap_4
X_4958_ _4958_/Y _4958_/A VDD VSS sg13cmos5l_inv_1
X_4889_ _4890_/B _5014_/A _4947_/B _4889_/C VDD VSS sg13cmos5l_nor3_1
X_7677_ _7677_/Q clkload5/A _7677_/D fanout386/X VDD VSS sg13cmos5l_dfrbpq_1
X_6628_ _6629_/B _6626_/B _7697_/Q VDD VSS sg13cmos5l_nand2b_1
X_6559_ _6567_/B _6559_/A VDD VSS sg13cmos5l_inv_1
XFILLER_75_724 VDD VSS sg13cmos5l_decap_8
XFILLER_75_768 VDD VSS sg13cmos5l_fill_2
XFILLER_47_459 VDD VSS sg13cmos5l_decap_8
XFILLER_42_153 VDD VSS sg13cmos5l_fill_1
XFILLER_42_186 VDD VSS sg13cmos5l_fill_2
XFILLER_51_83 VDD VSS sg13cmos5l_decap_8
XFILLER_78_562 VDD VSS sg13cmos5l_decap_4
XFILLER_78_584 VDD VSS sg13cmos5l_fill_1
XFILLER_38_437 VDD VSS sg13cmos5l_decap_4
XFILLER_18_4 VDD VSS sg13cmos5l_decap_8
XFILLER_65_201 VDD VSS sg13cmos5l_fill_2
X_5930_ _5936_/C _5931_/B _5930_/B VDD VSS sg13cmos5l_nand2b_1
XFILLER_80_248 VDD VSS sg13cmos5l_decap_8
XFILLER_74_790 VDD VSS sg13cmos5l_decap_8
X_7600_ _7601_/B _7600_/A _7627_/A VDD VSS sg13cmos5l_nand2_2
X_5861_ _5862_/B _6085_/A _5861_/B VDD VSS sg13cmos5l_xnor2_1
X_5792_ _5857_/S _5859_/B1 _5858_/A _5792_/B1 _6026_/B2 VDD VSS sg13cmos5l_a22oi_1
X_4812_ _4813_/B _5370_/B1 _5258_/A _5310_/B1 _5259_/A VDD VSS sg13cmos5l_a22oi_1
X_7531_ _7533_/A _7531_/A _7531_/B VDD VSS sg13cmos5l_nand2_1
X_4743_ _4796_/A _4694_/B _4694_/A _4742_/X VDD VSS sg13cmos5l_a21oi_1
Xrebuffer619 _7540_/B _7232_/A VDD VSS sg13cmos5l_buf_1
X_7462_ _7598_/A _7594_/A _7595_/A _7594_/B VDD VSS sg13cmos5l_nand3_1
X_4674_ _4683_/A _4622_/B _4487_/X _4674_/S VDD VSS sg13cmos5l_mux2_1
X_6413_ _6823_/A _7673_/Q _6413_/B VDD VSS sg13cmos5l_xnor2_1
X_7393_ _7408_/A _7393_/A _7567_/A VDD VSS sg13cmos5l_nor2b_2
X_6344_ _6638_/B _6720_/A _6516_/A _6353_/A _6533_/C VDD VSS sg13cmos5l_nor4_1
X_6275_ _6276_/A _6275_/A _6275_/B VDD VSS sg13cmos5l_nand2_1
X_5226_ _5227_/B _5295_/A _5295_/B VDD VSS sg13cmos5l_xor2_1
X_5157_ _5157_/Y _5157_/A VDD VSS sg13cmos5l_inv_1
XFILLER_57_713 VDD VSS sg13cmos5l_fill_1
X_4108_ _4143_/B _4109_/A _4108_/B _4108_/C VDD VSS sg13cmos5l_and3_1
X_5088_ _5158_/B _5088_/A _5088_/B VDD VSS sg13cmos5l_xor2_1
X_4039_ _4102_/B _4067_/A _4067_/B VDD VSS sg13cmos5l_xor2_1
Xbank_B_sram.gen_ihp_256x32.u_sram_256x32_505 bank_B_sram.gen_ihp_256x32.u_sram_256x32_505/L_LO
+ VDD VSS sg13cmos5l_tielo
Xbank_B_sram.gen_ihp_256x32.u_sram_256x32_516 bank_B_sram.gen_ihp_256x32.u_sram_256x32_516/L_LO
+ VDD VSS sg13cmos5l_tielo
XFILLER_56_267 VDD VSS sg13cmos5l_fill_2
XFILLER_71_237 VDD VSS sg13cmos5l_decap_4
Xbank_B_sram.gen_ihp_256x32.u_sram_256x32_538 bank_B_sram.gen_ihp_256x32.u_sram_256x32_538/L_LO
+ VDD VSS sg13cmos5l_tielo
Xbank_B_sram.gen_ihp_256x32.u_sram_256x32_527 bank_B_sram.gen_ihp_256x32.u_sram_256x32_527/L_LO
+ VDD VSS sg13cmos5l_tielo
XFILLER_52_495 VDD VSS sg13cmos5l_decap_8
XFILLER_79_359 VDD VSS sg13cmos5l_decap_8
XFILLER_75_543 VDD VSS sg13cmos5l_fill_2
XFILLER_47_234 VDD VSS sg13cmos5l_fill_2
XFILLER_75_587 VDD VSS sg13cmos5l_fill_1
XFILLER_35_429 VDD VSS sg13cmos5l_decap_8
XFILLER_46_50 VDD VSS sg13cmos5l_decap_8
XFILLER_46_83 VDD VSS sg13cmos5l_decap_4
XFILLER_63_749 VDD VSS sg13cmos5l_decap_4
XFILLER_43_462 VDD VSS sg13cmos5l_decap_8
XFILLER_62_82 VDD VSS sg13cmos5l_decap_8
XFILLER_7_22 VDD VSS sg13cmos5l_decap_8
X_4390_ _4391_/B _4525_/A _4647_/B _4390_/C VDD VSS sg13cmos5l_nor3_1
X_6060_ _6061_/B _6085_/A _6060_/B VDD VSS sg13cmos5l_xnor2_1
X_5011_ _5382_/A _5011_/A VDD VSS sg13cmos5l_buf_1
XFILLER_39_735 VDD VSS sg13cmos5l_decap_8
XFILLER_66_543 VDD VSS sg13cmos5l_decap_8
XFILLER_66_576 VDD VSS sg13cmos5l_fill_1
XFILLER_38_256 VDD VSS sg13cmos5l_decap_8
XFILLER_54_716 VDD VSS sg13cmos5l_decap_8
X_6962_ _6962_/X _6962_/A _6968_/B VDD VSS sg13cmos5l_and2_1
XFILLER_81_568 VDD VSS sg13cmos5l_decap_8
XFILLER_50_900 VDD VSS sg13cmos5l_fill_1
X_6893_ _6894_/B _7397_/A _6834_/Y _7313_/A _6892_/Y VDD VSS sg13cmos5l_a22oi_1
X_5913_ _5913_/X _5913_/A _5913_/B VDD VSS sg13cmos5l_and2_1
X_5844_ _5847_/A _5848_/C _5889_/B VDD VSS sg13cmos5l_nand2_1
XFILLER_62_782 VDD VSS sg13cmos5l_decap_4
X_7514_ _7515_/B _7517_/B _7514_/B VDD VSS sg13cmos5l_nand2_1
X_5775_ _5775_/Y _5775_/A VDD VSS sg13cmos5l_inv_1
X_4726_ _4726_/X _4726_/A _4726_/B VDD VSS sg13cmos5l_and2_1
X_4657_ _4660_/A _4713_/B _4657_/B VDD VSS sg13cmos5l_xnor2_1
X_7445_ _7452_/A _7472_/A1 _7356_/Y _7472_/B1 VDD VSS sg13cmos5l_o21ai_1
Xinput91 _7710_/D quant_cfg[19] VDD VSS sg13cmos5l_buf_1
Xinput80 input80/X bank_B_wdata[8] VDD VSS sg13cmos5l_buf_1
X_7376_ _7377_/A _7404_/A _7376_/B VDD VSS sg13cmos5l_nor2_1
X_4588_ _4589_/C _4932_/A VDD VSS sg13cmos5l_inv_1
X_6327_ _6329_/A _6328_/A _6391_/A _7665_/Q VDD VSS sg13cmos5l_a21oi_1
XFILLER_67_38 VDD VSS sg13cmos5l_fill_2
XFILLER_67_27 VDD VSS sg13cmos5l_decap_8
X_6258_ _6267_/A _6268_/A _6704_/A VDD VSS sg13cmos5l_nand2_1
X_5209_ _5210_/B _5443_/A _5644_/A2 _5382_/A _5644_/B2 VDD VSS sg13cmos5l_a22oi_1
X_6189_ _6189_/Y _6189_/A VDD VSS sg13cmos5l_inv_1
XFILLER_83_15 VDD VSS sg13cmos5l_decap_8
XFILLER_45_727 VDD VSS sg13cmos5l_decap_8
XFILLER_72_546 VDD VSS sg13cmos5l_fill_2
XFILLER_72_535 VDD VSS sg13cmos5l_fill_2
XFILLER_72_579 VDD VSS sg13cmos5l_fill_1
XFILLER_41_933 VDD VSS sg13cmos5l_fill_1
XFILLER_53_782 VDD VSS sg13cmos5l_fill_1
XFILLER_79_156 VDD VSS sg13cmos5l_decap_8
XFILLER_36_705 VDD VSS sg13cmos5l_fill_2
XFILLER_35_204 VDD VSS sg13cmos5l_decap_4
XFILLER_57_82 VDD VSS sg13cmos5l_decap_8
XFILLER_63_524 VDD VSS sg13cmos5l_fill_1
XFILLER_63_579 VDD VSS sg13cmos5l_decap_8
XFILLER_44_793 VDD VSS sg13cmos5l_fill_1
XFILLER_50_229 VDD VSS sg13cmos5l_decap_8
X_5560_ _5563_/A _5621_/S _5560_/B VDD VSS sg13cmos5l_xnor2_1
X_4511_ _4511_/X _4511_/A VDD VSS sg13cmos5l_buf_1
X_5491_ _5601_/A _5437_/B _5437_/A _5490_/Y VDD VSS sg13cmos5l_a21oi_1
X_7230_ _7531_/A _7230_/A VDD VSS sg13cmos5l_inv_1
X_4442_ _4443_/B _4574_/A _4640_/A _4511_/A _4641_/A VDD VSS sg13cmos5l_a22oi_1
X_7161_ _7163_/A _7161_/A _7191_/B VDD VSS sg13cmos5l_nand2_1
X_4373_ _4374_/B _4155_/X _4429_/A _3964_/C _4430_/A VDD VSS sg13cmos5l_a22oi_1
X_6112_ _6138_/A _6110_/B _6111_/A _6110_/Y _6111_/Y VDD VSS sg13cmos5l_a22oi_1
XFILLER_59_808 VDD VSS sg13cmos5l_fill_2
X_7092_ _7092_/Y _7081_/Y _7084_/Y _7249_/B _7051_/X _7327_/A VDD VSS sg13cmos5l_a221oi_1
X_6043_ _6076_/A _6160_/B _6008_/A _6007_/Y VDD VSS sg13cmos5l_o21ai_1
XFILLER_58_329 VDD VSS sg13cmos5l_decap_8
XFILLER_67_830 VDD VSS sg13cmos5l_decap_8
XFILLER_67_863 VDD VSS sg13cmos5l_decap_4
XFILLER_81_310 VDD VSS sg13cmos5l_decap_8
XFILLER_42_719 VDD VSS sg13cmos5l_decap_4
XFILLER_54_557 VDD VSS sg13cmos5l_decap_8
XFILLER_54_568 VDD VSS sg13cmos5l_fill_1
X_6945_ _6945_/X _6945_/A _6947_/B VDD VSS sg13cmos5l_and2_1
XFILLER_81_387 VDD VSS sg13cmos5l_decap_8
X_6876_ _6877_/B _6875_/X _7021_/A VDD VSS sg13cmos5l_nand2b_1
XFILLER_50_763 VDD VSS sg13cmos5l_fill_1
X_5827_ _5829_/A _5774_/A _5827_/B VDD VSS sg13cmos5l_nand2b_1
X_5758_ _5817_/A _5758_/A _5813_/A VDD VSS sg13cmos5l_xnor2_1
X_4709_ _4710_/B _4746_/A _4709_/B VDD VSS sg13cmos5l_xnor2_1
X_7428_ _7429_/B _7428_/A VDD VSS sg13cmos5l_buf_1
X_5689_ _5692_/A _5744_/S _5689_/B VDD VSS sg13cmos5l_xnor2_1
X_7359_ _7513_/B _7359_/A _7374_/B VDD VSS sg13cmos5l_nand2_1
XFILLER_78_59 VDD VSS sg13cmos5l_fill_1
XFILLER_49_329 VDD VSS sg13cmos5l_decap_8
XFILLER_94_25 VDD VSS sg13cmos5l_decap_4
Xhold2095 _7150_/B _7717_/Q VDD VSS sg13cmos5l_dlygate4sd3_1
Xhold2084 _6195_/A _7724_/Q VDD VSS sg13cmos5l_dlygate4sd3_1
XFILLER_57_340 VDD VSS sg13cmos5l_fill_2
XFILLER_58_863 VDD VSS sg13cmos5l_decap_4
XFILLER_73_833 VDD VSS sg13cmos5l_fill_2
XFILLER_73_822 VDD VSS sg13cmos5l_decap_8
XFILLER_45_557 VDD VSS sg13cmos5l_decap_8
XFILLER_53_590 VDD VSS sg13cmos5l_fill_2
XFILLER_60_549 VDD VSS sg13cmos5l_decap_4
Xrebuffer780 _7620_/C _7565_/C VDD VSS sg13cmos5l_buf_1
XFILLER_68_616 VDD VSS sg13cmos5l_fill_2
XFILLER_68_649 VDD VSS sg13cmos5l_fill_1
XFILLER_49_863 VDD VSS sg13cmos5l_fill_1
XFILLER_49_885 VDD VSS sg13cmos5l_fill_1
XFILLER_82_129 VDD VSS sg13cmos5l_fill_1
XFILLER_75_181 VDD VSS sg13cmos5l_decap_8
XFILLER_48_384 VDD VSS sg13cmos5l_decap_4
XFILLER_63_310 VDD VSS sg13cmos5l_fill_1
XFILLER_64_822 VDD VSS sg13cmos5l_fill_2
X_6730_ _6974_/B _6915_/A VDD VSS sg13cmos5l_buf_1
X_4991_ _5046_/A _4938_/B _4938_/A _4990_/X VDD VSS sg13cmos5l_a21oi_1
X_3942_ _5206_/A _3953_/C VDD VSS sg13cmos5l_buf_1
X_6661_ _6670_/A _6661_/A _6661_/B _6733_/B VDD VSS sg13cmos5l_nand3_1
X_5612_ _5618_/C _5613_/B _5612_/B VDD VSS sg13cmos5l_nand2b_1
X_6592_ _6594_/A _6592_/A _6765_/A VDD VSS sg13cmos5l_nand2_2
X_5543_ _5545_/A _5544_/A _5544_/C _5544_/B VDD VSS sg13cmos5l_a21oi_1
X_5474_ _5475_/B _5474_/A _5474_/B VDD VSS sg13cmos5l_xor2_1
X_7213_ _7214_/B _6416_/A _7209_/Y _7212_/Y VDD VSS sg13cmos5l_o21ai_1
X_4425_ _4486_/B _4489_/B _4489_/A VDD VSS sg13cmos5l_xor2_1
XFILLER_59_605 VDD VSS sg13cmos5l_decap_8
X_4356_ _4358_/A _4356_/A VDD VSS sg13cmos5l_inv_1
X_7144_ _7144_/Y _7144_/A _7181_/A _7144_/C VDD VSS sg13cmos5l_nand3_1
XFILLER_48_18 VDD VSS sg13cmos5l_decap_4
XFILLER_58_104 VDD VSS sg13cmos5l_fill_1
X_4287_ _4297_/A _4226_/A _4285_/Y _4286_/Y VDD VSS sg13cmos5l_o21ai_1
X_7075_ _7246_/B _7075_/A VDD VSS sg13cmos5l_inv_1
XFILLER_74_619 VDD VSS sg13cmos5l_fill_1
X_6026_ _6056_/S _6058_/B1 _6114_/A _6026_/B1 _6026_/B2 VDD VSS sg13cmos5l_a22oi_1
XFILLER_73_129 VDD VSS sg13cmos5l_decap_8
XFILLER_67_693 VDD VSS sg13cmos5l_fill_1
XFILLER_67_682 VDD VSS sg13cmos5l_decap_4
XFILLER_54_310 VDD VSS sg13cmos5l_fill_2
XFILLER_81_184 VDD VSS sg13cmos5l_decap_8
XFILLER_35_590 VDD VSS sg13cmos5l_fill_1
X_6928_ _6928_/Y _6770_/Y _6927_/B _6927_/Y VDD VSS sg13cmos5l_o21ai_1
XFILLER_80_27 VDD VSS sg13cmos5l_decap_8
X_6859_ _6859_/Y _6846_/Y _6900_/C _6858_/Y VDD VSS sg13cmos5l_a21oi_1
XFILLER_58_660 VDD VSS sg13cmos5l_fill_2
XFILLER_38_95 VDD VSS sg13cmos5l_decap_8
XFILLER_64_118 VDD VSS sg13cmos5l_decap_8
XFILLER_73_663 VDD VSS sg13cmos5l_fill_2
XFILLER_57_192 VDD VSS sg13cmos5l_decap_8
XFILLER_60_324 VDD VSS sg13cmos5l_decap_8
XFILLER_41_582 VDD VSS sg13cmos5l_fill_1
X_4210_ _4211_/B _4210_/A _4210_/B VDD VSS sg13cmos5l_xor2_1
X_5190_ _5190_/X _5190_/A VDD VSS sg13cmos5l_buf_1
X_4141_ _4142_/A _4146_/B _4146_/A VDD VSS sg13cmos5l_xor2_1
Xclkbuf_0_clk_i clkbuf_0_clk_i/X clkbuf_0_clk_i/A VDD VSS sg13cmos5l_buf_8
Xbank_A_sram.gen_ihp_256x32.u_sram_256x32_470 bank_A_sram.gen_ihp_256x32.u_sram_256x32_470/L_LO
+ VDD VSS sg13cmos5l_tielo
X_4072_ _4138_/B _4072_/A _4576_/A VDD VSS sg13cmos5l_nor2b_1
XFILLER_37_844 VDD VSS sg13cmos5l_decap_8
XFILLER_63_173 VDD VSS sg13cmos5l_fill_2
XFILLER_36_398 VDD VSS sg13cmos5l_decap_8
X_4974_ _4974_/X _4974_/A _4974_/B VDD VSS sg13cmos5l_and2_1
XFILLER_52_869 VDD VSS sg13cmos5l_fill_2
X_6713_ _6990_/A _6713_/A _6713_/B _6896_/B VDD VSS sg13cmos5l_nand3_1
X_7693_ _7693_/Q clkload2/A _7693_/D fanout393/X VDD VSS sg13cmos5l_dfrbpq_1
X_6644_ _6660_/B _7700_/Q VDD VSS sg13cmos5l_inv_1
XFILLER_60_891 VDD VSS sg13cmos5l_decap_8
Xclkload8 clkload8/Y clkload8/A VDD VSS sg13cmos5l_inv_1
X_6575_ _6583_/A _6770_/B _6575_/B VDD VSS sg13cmos5l_nand2_2
X_5526_ _5566_/A _5526_/A _5565_/A VDD VSS sg13cmos5l_xnor2_1
X_5457_ _5755_/A _5457_/A VDD VSS sg13cmos5l_buf_1
XFILLER_59_39 VDD VSS sg13cmos5l_decap_8
X_4408_ _4470_/A _4408_/A _4467_/A VDD VSS sg13cmos5l_xnor2_1
Xfanout201 _5460_/B _5142_/X VDD VSS sg13cmos5l_buf_1
Xfanout223 _5116_/A _4561_/X VDD VSS sg13cmos5l_buf_1
X_5388_ _5404_/A _5388_/A _5388_/B VDD VSS sg13cmos5l_xor2_1
Xfanout212 _5941_/A2 _5568_/X VDD VSS sg13cmos5l_buf_1
X_7127_ _7127_/Y _7127_/A _7134_/B VDD VSS sg13cmos5l_nand2_1
Xfanout256 _7072_/B _7078_/B VDD VSS sg13cmos5l_buf_1
Xfanout234 _7181_/A _7195_/B VDD VSS sg13cmos5l_buf_1
XFILLER_59_446 VDD VSS sg13cmos5l_fill_1
XFILLER_59_435 VDD VSS sg13cmos5l_decap_8
Xfanout245 _4997_/A _4430_/X VDD VSS sg13cmos5l_buf_1
X_4339_ _4340_/B _4404_/B _4404_/A VDD VSS sg13cmos5l_xor2_1
Xfanout278 _7352_/A _7366_/A VDD VSS sg13cmos5l_buf_1
XFILLER_75_27 VDD VSS sg13cmos5l_decap_4
Xfanout267 _5788_/A _5676_/B VDD VSS sg13cmos5l_buf_1
Xfanout289 _7111_/A _7158_/A VDD VSS sg13cmos5l_buf_1
X_7058_ _7058_/Y _7050_/Y _7153_/A _7057_/Y VDD VSS sg13cmos5l_a21oi_2
XFILLER_59_468 VDD VSS sg13cmos5l_fill_1
X_6009_ _6013_/B _6128_/A _6009_/B VDD VSS sg13cmos5l_xnor2_1
XFILLER_91_15 VDD VSS sg13cmos5l_decap_8
XFILLER_70_611 VDD VSS sg13cmos5l_fill_1
XFILLER_70_600 VDD VSS sg13cmos5l_decap_8
XFILLER_54_173 VDD VSS sg13cmos5l_decap_4
XFILLER_70_677 VDD VSS sg13cmos5l_decap_8
XFILLER_42_357 VDD VSS sg13cmos5l_decap_8
XFILLER_78_777 VDD VSS sg13cmos5l_decap_8
XFILLER_77_254 VDD VSS sg13cmos5l_decap_8
XFILLER_65_438 VDD VSS sg13cmos5l_decap_4
XFILLER_46_630 VDD VSS sg13cmos5l_decap_8
XFILLER_65_60 VDD VSS sg13cmos5l_fill_2
XFILLER_60_110 VDD VSS sg13cmos5l_fill_1
XFILLER_60_165 VDD VSS sg13cmos5l_decap_8
X_4690_ _4742_/A _4871_/A _4690_/B VDD VSS sg13cmos5l_xnor2_1
X_6360_ _6362_/A _6361_/A _6391_/A _7668_/Q VDD VSS sg13cmos5l_a21oi_1
X_5311_ _5312_/B _5493_/B1 _5685_/A _5430_/B1 _5686_/A VDD VSS sg13cmos5l_a22oi_1
X_6291_ _6595_/B _6353_/A _6291_/B VDD VSS sg13cmos5l_nor2_1
X_5242_ _5290_/A _5302_/A _5304_/B VDD VSS sg13cmos5l_xnor2_1
X_5173_ _5173_/X _5173_/A _5173_/B VDD VSS sg13cmos5l_and2_1
X_4124_ _4134_/A _4168_/A _4124_/B VDD VSS sg13cmos5l_xnor2_1
XFILLER_69_766 VDD VSS sg13cmos5l_decap_8
XFILLER_56_405 VDD VSS sg13cmos5l_fill_1
XFILLER_68_298 VDD VSS sg13cmos5l_decap_8
Xinput1 input1/X bank_A_addr[0] VDD VSS sg13cmos5l_buf_1
X_4055_ _4058_/B _3955_/A _4310_/A _3961_/A VDD VSS sg13cmos5l_a21oi_1
XFILLER_36_151 VDD VSS sg13cmos5l_decap_8
XFILLER_64_471 VDD VSS sg13cmos5l_fill_1
XFILLER_37_696 VDD VSS sg13cmos5l_fill_2
XFILLER_64_493 VDD VSS sg13cmos5l_fill_1
XFILLER_51_143 VDD VSS sg13cmos5l_fill_1
X_4957_ _5030_/B _5025_/A _4957_/B VDD VSS sg13cmos5l_xnor2_1
XFILLER_51_176 VDD VSS sg13cmos5l_fill_1
XFILLER_52_699 VDD VSS sg13cmos5l_fill_1
X_4888_ _4889_/C _5257_/A VDD VSS sg13cmos5l_inv_1
X_7676_ _7676_/Q clkload5/A _7676_/D fanout386/X VDD VSS sg13cmos5l_dfrbpq_1
X_6627_ _6629_/A _6627_/A _6753_/A VDD VSS sg13cmos5l_nand2_2
X_6558_ _6559_/A _6630_/A _6698_/B VDD VSS sg13cmos5l_nor2_1
X_5509_ _5561_/B _5872_/A _5509_/B VDD VSS sg13cmos5l_xnor2_1
X_6489_ _6504_/B _7682_/Q VDD VSS sg13cmos5l_inv_1
XFILLER_75_703 VDD VSS sg13cmos5l_fill_1
XFILLER_47_438 VDD VSS sg13cmos5l_decap_4
XFILLER_59_276 VDD VSS sg13cmos5l_fill_1
XFILLER_74_268 VDD VSS sg13cmos5l_fill_2
XFILLER_35_52 VDD VSS sg13cmos5l_decap_8
XFILLER_35_63 VDD VSS sg13cmos5l_decap_8
XFILLER_70_496 VDD VSS sg13cmos5l_fill_1
XFILLER_70_485 VDD VSS sg13cmos5l_fill_1
XFILLER_54_909 VDD VSS sg13cmos5l_fill_2
XFILLER_65_246 VDD VSS sg13cmos5l_fill_2
XFILLER_65_257 VDD VSS sg13cmos5l_decap_8
XFILLER_81_717 VDD VSS sg13cmos5l_fill_2
XFILLER_80_227 VDD VSS sg13cmos5l_decap_8
X_5860_ _5861_/B _5985_/B1 _6027_/A2 _5949_/B1 _6027_/B2 VDD VSS sg13cmos5l_a22oi_1
X_4811_ _4811_/X _4811_/A VDD VSS sg13cmos5l_buf_1
XFILLER_61_452 VDD VSS sg13cmos5l_decap_8
X_5791_ _5800_/A _5748_/B _5415_/A _5791_/S VDD VSS sg13cmos5l_mux2_1
X_7530_ _7613_/B _7530_/A _7530_/B VDD VSS sg13cmos5l_xnor2_1
X_4742_ _4742_/X _4742_/A _4742_/B VDD VSS sg13cmos5l_and2_1
X_7461_ _7594_/B _7461_/A _7464_/B VDD VSS sg13cmos5l_nand2_1
X_4673_ _4732_/A _4626_/B _4626_/A _4672_/Y VDD VSS sg13cmos5l_a21oi_1
X_6412_ _6413_/B _6409_/Y _6421_/A _6391_/X VDD VSS sg13cmos5l_o21ai_1
X_7392_ _7567_/A _7557_/A _7570_/A VDD VSS sg13cmos5l_xnor2_1
X_6343_ _6408_/A _6343_/A VDD VSS sg13cmos5l_buf_1
X_6274_ _6799_/B _6805_/A _6804_/A _6273_/Y VDD VSS sg13cmos5l_o21ai_1
X_5225_ _5295_/B _5225_/A _5225_/B VDD VSS sg13cmos5l_xnor2_1
XFILLER_69_541 VDD VSS sg13cmos5l_decap_8
X_5156_ _5160_/A _5217_/B _5156_/B VDD VSS sg13cmos5l_xnor2_1
XFILLER_56_213 VDD VSS sg13cmos5l_decap_8
X_4107_ _4144_/A _4107_/A _4106_/A VDD VSS sg13cmos5l_nor2b_1
X_5087_ _5088_/B _5127_/A _5087_/B VDD VSS sg13cmos5l_xnor2_1
X_4038_ _4067_/B _4012_/B _4012_/A _4037_/Y VDD VSS sg13cmos5l_a21oi_2
Xbank_B_sram.gen_ihp_256x32.u_sram_256x32_506 bank_B_sram.gen_ihp_256x32.u_sram_256x32_506/L_LO
+ VDD VSS sg13cmos5l_tielo
Xbank_B_sram.gen_ihp_256x32.u_sram_256x32_539 bank_B_sram.gen_ihp_256x32.u_sram_256x32_539/L_LO
+ VDD VSS sg13cmos5l_tielo
Xbank_B_sram.gen_ihp_256x32.u_sram_256x32_517 bank_B_sram.gen_ihp_256x32.u_sram_256x32_517/L_LO
+ VDD VSS sg13cmos5l_tielo
Xbank_B_sram.gen_ihp_256x32.u_sram_256x32_528 bank_B_sram.gen_ihp_256x32.u_sram_256x32_528/L_LO
+ VDD VSS sg13cmos5l_tielo
X_5989_ _5991_/A _5989_/A _5945_/A VDD VSS sg13cmos5l_nor2b_1
X_7728_ _7728_/Q _7728_/CLK _7728_/D fanout391/X VDD VSS sg13cmos5l_dfrbpq_1
X_7659_ _7659_/Q _7675_/CLK _7659_/D fanout387/X VDD VSS sg13cmos5l_dfrbpq_1
XFILLER_97_14 VDD VSS sg13cmos5l_decap_8
XFILLER_79_338 VDD VSS sg13cmos5l_decap_8
XFILLER_75_511 VDD VSS sg13cmos5l_decap_8
XFILLER_48_725 VDD VSS sg13cmos5l_fill_2
XFILLER_75_577 VDD VSS sg13cmos5l_fill_2
XFILLER_35_419 VDD VSS sg13cmos5l_fill_2
XFILLER_44_920 VDD VSS sg13cmos5l_decap_8
XFILLER_55_290 VDD VSS sg13cmos5l_fill_2
XFILLER_87_8 VDD VSS sg13cmos5l_decap_8
X_5010_ _5020_/A _5010_/A _5010_/B VDD VSS sg13cmos5l_xnor2_1
XFILLER_79_894 VDD VSS sg13cmos5l_fill_2
XFILLER_66_511 VDD VSS sg13cmos5l_decap_4
XFILLER_39_758 VDD VSS sg13cmos5l_decap_8
XFILLER_38_235 VDD VSS sg13cmos5l_decap_8
XFILLER_66_588 VDD VSS sg13cmos5l_decap_4
XFILLER_81_547 VDD VSS sg13cmos5l_decap_8
X_6961_ _6961_/Y _6816_/A _6957_/S _6960_/X VDD VSS sg13cmos5l_a21oi_1
XFILLER_66_599 VDD VSS sg13cmos5l_fill_2
X_5912_ _5915_/A _5948_/S _5912_/B VDD VSS sg13cmos5l_xnor2_1
X_6892_ _6892_/Y _7076_/B _6859_/Y _6891_/Y VDD VSS sg13cmos5l_o21ai_1
X_5843_ _5889_/B _5842_/B _5843_/B VDD VSS sg13cmos5l_nand2b_1
XFILLER_61_282 VDD VSS sg13cmos5l_fill_2
X_7513_ _7515_/A _7513_/A _7513_/B VDD VSS sg13cmos5l_nand2_1
X_5774_ _5834_/A _5774_/A _5827_/B VDD VSS sg13cmos5l_xnor2_1
X_4725_ _4729_/A _4725_/A VDD VSS sg13cmos5l_inv_1
X_4656_ _4657_/B _4656_/A _4714_/B VDD VSS sg13cmos5l_xor2_1
X_7444_ _7590_/A _7444_/A _7496_/A VDD VSS sg13cmos5l_nand2_2
X_4587_ _4590_/A _3931_/A _4932_/A _4387_/X VDD VSS sg13cmos5l_a21oi_1
X_7375_ _7381_/A _7375_/A _7506_/B _7507_/B VDD VSS sg13cmos5l_nand3_1
Xinput81 input81/X bank_B_wdata[9] VDD VSS sg13cmos5l_buf_1
Xinput70 input70/X bank_B_wdata[28] VDD VSS sg13cmos5l_buf_1
Xinput92 _7711_/D quant_cfg[20] VDD VSS sg13cmos5l_buf_1
X_6326_ _6372_/C _6328_/C VDD VSS sg13cmos5l_buf_4
X_6257_ _6805_/A _6802_/A _7659_/Q _6275_/B VDD VSS sg13cmos5l_nand3_1
X_5208_ _5266_/A _5460_/B _5505_/A _5207_/Y VDD VSS sg13cmos5l_a21o_1
X_6188_ _6188_/Y _6183_/Y _6209_/A1 _6187_/Y VDD VSS sg13cmos5l_a21oi_1
X_5139_ _5186_/A _5086_/B _5086_/A _5138_/Y VDD VSS sg13cmos5l_a21oi_1
XFILLER_44_249 VDD VSS sg13cmos5l_decap_4
XFILLER_41_912 VDD VSS sg13cmos5l_decap_8
XFILLER_79_124 VDD VSS sg13cmos5l_decap_8
XFILLER_79_135 VDD VSS sg13cmos5l_decap_8
XFILLER_76_853 VDD VSS sg13cmos5l_fill_2
XFILLER_57_50 VDD VSS sg13cmos5l_fill_2
XFILLER_76_864 VDD VSS sg13cmos5l_decap_8
XFILLER_75_341 VDD VSS sg13cmos5l_fill_1
XFILLER_75_396 VDD VSS sg13cmos5l_fill_2
XFILLER_35_227 VDD VSS sg13cmos5l_decap_8
XFILLER_63_547 VDD VSS sg13cmos5l_fill_2
XFILLER_44_772 VDD VSS sg13cmos5l_decap_8
XFILLER_50_208 VDD VSS sg13cmos5l_decap_8
X_5490_ _5490_/Y _5490_/A _5436_/A VDD VSS sg13cmos5l_nor2b_1
X_4510_ _4517_/A _5060_/A _4510_/B VDD VSS sg13cmos5l_xnor2_1
X_4441_ _4506_/A _4396_/B _4396_/A _4440_/Y VDD VSS sg13cmos5l_a21oi_1
X_7160_ _7184_/B _7160_/A VDD VSS sg13cmos5l_buf_1
X_6111_ _6111_/Y _6111_/A _6111_/B VDD VSS sg13cmos5l_nor2_1
X_4372_ _4403_/A _4416_/B _4416_/A VDD VSS sg13cmos5l_xor2_1
X_7091_ _7349_/A _7091_/A VDD VSS sg13cmos5l_buf_1
X_6042_ _6175_/B _6042_/A VDD VSS sg13cmos5l_buf_1
XFILLER_58_308 VDD VSS sg13cmos5l_fill_1
XFILLER_66_341 VDD VSS sg13cmos5l_fill_2
XFILLER_82_845 VDD VSS sg13cmos5l_fill_2
XFILLER_39_599 VDD VSS sg13cmos5l_decap_8
XFILLER_54_536 VDD VSS sg13cmos5l_decap_8
X_6944_ _6944_/Y _6940_/Y _6913_/B _6943_/Y VDD VSS sg13cmos5l_a21oi_1
XFILLER_81_366 VDD VSS sg13cmos5l_decap_8
XFILLER_41_208 VDD VSS sg13cmos5l_decap_8
X_6875_ _6875_/X _6872_/Y _6957_/S _6874_/Y VDD VSS sg13cmos5l_a21o_1
XFILLER_62_591 VDD VSS sg13cmos5l_fill_1
X_5826_ _5833_/B _5826_/A VDD VSS sg13cmos5l_inv_1
X_5757_ _5813_/A _5810_/B _5757_/B VDD VSS sg13cmos5l_xnor2_1
X_4708_ _4709_/B _4708_/A _4708_/B VDD VSS sg13cmos5l_xor2_1
X_7427_ _7428_/A _7326_/Y _7397_/A _7399_/A VDD VSS sg13cmos5l_a21o_1
X_5688_ _5689_/B _5793_/A _5688_/B VDD VSS sg13cmos5l_xnor2_1
X_4639_ _4684_/A _4595_/B _4595_/A _4638_/Y VDD VSS sg13cmos5l_a21oi_1
X_7358_ _7359_/A _7404_/A _7196_/Y _7357_/Y VDD VSS sg13cmos5l_o21ai_1
X_6309_ _6310_/A _6309_/A _6786_/A VDD VSS sg13cmos5l_nand2_2
X_7289_ _7290_/C _7289_/A _7289_/B VDD VSS sg13cmos5l_nor2_1
XFILLER_76_149 VDD VSS sg13cmos5l_fill_2
XFILLER_58_831 VDD VSS sg13cmos5l_fill_2
Xhold2085 _6197_/A2 _6195_/Y VDD VSS sg13cmos5l_dlygate4sd3_1
XFILLER_45_536 VDD VSS sg13cmos5l_decap_4
XFILLER_43_85 VDD VSS sg13cmos5l_fill_1
Xrebuffer770 rebuffer770/X _6670_/A VDD VSS sg13cmos5l_buf_1
Xrebuffer781 _6565_/B _6303_/A VDD VSS sg13cmos5l_buf_1
XFILLER_4_13 VDD VSS sg13cmos5l_decap_8
XFILLER_68_628 VDD VSS sg13cmos5l_fill_1
XFILLER_68_60 VDD VSS sg13cmos5l_decap_8
XFILLER_36_547 VDD VSS sg13cmos5l_decap_8
XFILLER_63_333 VDD VSS sg13cmos5l_fill_1
XFILLER_51_506 VDD VSS sg13cmos5l_decap_4
X_4990_ _4990_/X _4990_/A _4990_/B VDD VSS sg13cmos5l_and2_1
XFILLER_63_366 VDD VSS sg13cmos5l_fill_1
X_3941_ _3953_/C _4525_/A VDD VSS sg13cmos5l_buf_1
X_6660_ _6733_/B _6660_/A _6660_/B VDD VSS sg13cmos5l_nand2_1
X_6591_ _6765_/A _7693_/Q _6591_/B VDD VSS sg13cmos5l_xnor2_1
X_5611_ _5612_/B _5781_/A _5545_/A _5544_/Y VDD VSS sg13cmos5l_o21ai_1
X_5542_ _5544_/B _5542_/A _5542_/B VDD VSS sg13cmos5l_and2_1
X_5473_ _5474_/B _5473_/A _5473_/B VDD VSS sg13cmos5l_nand2_1
X_7212_ _7212_/Y _7265_/A _7211_/Y _7059_/A VDD VSS sg13cmos5l_o21ai_1
X_4424_ _4489_/A _4621_/A _4424_/B VDD VSS sg13cmos5l_xnor2_1
X_4355_ _4471_/A _4355_/A VDD VSS sg13cmos5l_inv_1
X_7143_ _7144_/C _6973_/Y _7162_/B VDD VSS sg13cmos5l_nand2b_1
X_7074_ _7075_/A _7070_/Y _7080_/A _7073_/Y VDD VSS sg13cmos5l_a21oi_1
X_4286_ _4286_/Y _4286_/A _4286_/B VDD VSS sg13cmos5l_nand2_1
XFILLER_104_25 VDD VSS sg13cmos5l_decap_4
X_6025_ _6049_/B _5983_/B _6025_/B VDD VSS sg13cmos5l_nand2b_1
XFILLER_54_333 VDD VSS sg13cmos5l_fill_2
XFILLER_66_182 VDD VSS sg13cmos5l_decap_4
XFILLER_81_163 VDD VSS sg13cmos5l_decap_8
XFILLER_70_826 VDD VSS sg13cmos5l_decap_8
XFILLER_54_388 VDD VSS sg13cmos5l_decap_8
XFILLER_55_889 VDD VSS sg13cmos5l_decap_8
X_6927_ _6927_/Y _6862_/X _6927_/B VDD VSS sg13cmos5l_nand2b_1
X_6858_ _6858_/Y _6900_/C _7112_/A VDD VSS sg13cmos5l_nor2_1
X_5809_ _5811_/A _5809_/A VDD VSS sg13cmos5l_buf_1
XFILLER_13_22 VDD VSS sg13cmos5l_decap_8
X_6789_ _6789_/Y _6896_/B _6974_/A _6788_/Y VDD VSS sg13cmos5l_o21ai_1
XFILLER_89_15 VDD VSS sg13cmos5l_decap_8
XFILLER_78_926 VDD VSS sg13cmos5l_decap_8
XFILLER_77_425 VDD VSS sg13cmos5l_fill_2
XFILLER_58_650 VDD VSS sg13cmos5l_fill_2
XFILLER_65_609 VDD VSS sg13cmos5l_fill_1
XFILLER_38_74 VDD VSS sg13cmos5l_decap_8
XFILLER_58_694 VDD VSS sg13cmos5l_fill_1
XFILLER_73_642 VDD VSS sg13cmos5l_decap_8
XFILLER_45_355 VDD VSS sg13cmos5l_fill_2
XFILLER_60_303 VDD VSS sg13cmos5l_fill_2
XFILLER_72_185 VDD VSS sg13cmos5l_fill_2
XFILLER_72_174 VDD VSS sg13cmos5l_decap_8
XFILLER_41_550 VDD VSS sg13cmos5l_fill_1
XFILLER_70_72 VDD VSS sg13cmos5l_decap_4
X_4140_ _4146_/A _4140_/A _4140_/B VDD VSS sg13cmos5l_nand2_2
XFILLER_69_926 VDD VSS sg13cmos5l_decap_8
Xbank_A_sram.gen_ihp_256x32.u_sram_256x32_460 bank_A_sram.gen_ihp_256x32.u_sram_256x32_460/L_LO
+ VDD VSS sg13cmos5l_tielo
X_4071_ _4576_/A _4207_/A VDD VSS sg13cmos5l_buf_1
XFILLER_36_333 VDD VSS sg13cmos5l_decap_8
XFILLER_64_675 VDD VSS sg13cmos5l_fill_1
XFILLER_64_686 VDD VSS sg13cmos5l_decap_8
XFILLER_36_388 VDD VSS sg13cmos5l_fill_1
X_4973_ _4977_/A _4973_/A VDD VSS sg13cmos5l_inv_1
XFILLER_51_325 VDD VSS sg13cmos5l_fill_1
XFILLER_63_196 VDD VSS sg13cmos5l_decap_8
X_6712_ _6800_/A _6957_/S VDD VSS sg13cmos5l_buf_2
X_7692_ _7692_/Q clkload0/A _7692_/D fanout383/X VDD VSS sg13cmos5l_dfrbpq_1
X_6643_ _6734_/A _6732_/B _6732_/A VDD VSS sg13cmos5l_nand2_2
Xclkload9 clkload9/Y clkload9/A VDD VSS sg13cmos5l_inv_1
X_6574_ _6575_/B _6570_/B _7691_/Q VDD VSS sg13cmos5l_nand2b_1
X_5525_ _5565_/A _5525_/A _5525_/B VDD VSS sg13cmos5l_xor2_1
X_5456_ _5466_/A _5456_/A _5456_/B VDD VSS sg13cmos5l_xnor2_1
X_4407_ _4467_/A _4407_/A _4407_/B VDD VSS sg13cmos5l_xor2_1
Xfanout202 _5683_/A _5116_/X VDD VSS sg13cmos5l_buf_1
X_5387_ _5388_/B _5434_/A _5434_/B VDD VSS sg13cmos5l_xor2_1
Xfanout213 _5943_/B2 _5448_/X VDD VSS sg13cmos5l_buf_1
Xfanout224 _5082_/A _4530_/X VDD VSS sg13cmos5l_buf_1
Xfanout235 _7289_/A _6418_/Y VDD VSS sg13cmos5l_buf_1
Xfanout246 _4641_/A _4122_/X VDD VSS sg13cmos5l_buf_1
X_7126_ _7126_/Y _7125_/Y _7126_/B VDD VSS sg13cmos5l_nand2b_1
X_4338_ _4404_/A _4283_/A _4336_/Y _4337_/Y VDD VSS sg13cmos5l_o21ai_1
Xfanout268 _5810_/B _5456_/A VDD VSS sg13cmos5l_buf_1
X_4269_ _4269_/Y _4269_/A _4269_/B VDD VSS sg13cmos5l_nor2_1
Xfanout279 _7265_/A _7297_/A VDD VSS sg13cmos5l_buf_1
Xfanout257 _7044_/A _7018_/B VDD VSS sg13cmos5l_buf_1
X_7057_ _7057_/Y _7076_/B _7057_/B VDD VSS sg13cmos5l_nor2_1
XFILLER_74_439 VDD VSS sg13cmos5l_fill_1
XFILLER_74_428 VDD VSS sg13cmos5l_decap_8
X_6008_ _6009_/B _6008_/A _6007_/Y VDD VSS sg13cmos5l_nor2b_1
XFILLER_46_108 VDD VSS sg13cmos5l_fill_1
XFILLER_67_491 VDD VSS sg13cmos5l_fill_1
XFILLER_39_182 VDD VSS sg13cmos5l_fill_1
XFILLER_82_450 VDD VSS sg13cmos5l_fill_1
XFILLER_42_303 VDD VSS sg13cmos5l_decap_8
XFILLER_43_859 VDD VSS sg13cmos5l_decap_8
XFILLER_70_667 VDD VSS sg13cmos5l_decap_4
XFILLER_51_881 VDD VSS sg13cmos5l_fill_1
XFILLER_51_870 VDD VSS sg13cmos5l_decap_8
XFILLER_40_97 VDD VSS sg13cmos5l_decap_8
XFILLER_78_701 VDD VSS sg13cmos5l_fill_1
XFILLER_49_40 VDD VSS sg13cmos5l_fill_2
XFILLER_77_233 VDD VSS sg13cmos5l_decap_8
XFILLER_65_50 VDD VSS sg13cmos5l_fill_1
XFILLER_80_409 VDD VSS sg13cmos5l_decap_8
XFILLER_46_697 VDD VSS sg13cmos5l_decap_8
XFILLER_42_870 VDD VSS sg13cmos5l_fill_2
XFILLER_42_892 VDD VSS sg13cmos5l_fill_1
XFILLER_81_93 VDD VSS sg13cmos5l_decap_8
XFILLER_41_391 VDD VSS sg13cmos5l_decap_8
X_6290_ _6291_/B _6376_/A _6720_/A _6290_/C VDD VSS sg13cmos5l_nand3_1
X_5310_ _5368_/A _5370_/B1 _5858_/A _5310_/B1 _5683_/A VDD VSS sg13cmos5l_a22oi_1
X_5241_ _5304_/B _5185_/B _5185_/A _5240_/Y VDD VSS sg13cmos5l_a21oi_1
X_5172_ _5172_/Y _5172_/A VDD VSS sg13cmos5l_inv_1
X_4123_ _4124_/B _4205_/A _4640_/A _4155_/A _4641_/A VDD VSS sg13cmos5l_a22oi_1
XFILLER_68_233 VDD VSS sg13cmos5l_decap_4
X_4054_ _4310_/A _4054_/A VDD VSS sg13cmos5l_buf_8
Xinput2 input2/X bank_A_addr[1] VDD VSS sg13cmos5l_buf_1
XFILLER_37_620 VDD VSS sg13cmos5l_fill_1
XFILLER_37_653 VDD VSS sg13cmos5l_fill_2
XFILLER_36_130 VDD VSS sg13cmos5l_decap_8
XFILLER_101_15 VDD VSS sg13cmos5l_decap_8
XFILLER_80_932 VDD VSS sg13cmos5l_fill_2
XFILLER_80_921 VDD VSS sg13cmos5l_decap_8
XFILLER_40_829 VDD VSS sg13cmos5l_fill_1
X_4956_ _4957_/B _4956_/A _5026_/B VDD VSS sg13cmos5l_xor2_1
X_4887_ _4890_/A _3931_/A _5257_/A _4944_/A VDD VSS sg13cmos5l_a21oi_1
XFILLER_51_199 VDD VSS sg13cmos5l_fill_1
X_7675_ _7675_/Q _7675_/CLK _7675_/D fanout386/X VDD VSS sg13cmos5l_dfrbpq_1
X_6626_ _6753_/A _7697_/Q _6626_/B VDD VSS sg13cmos5l_xnor2_1
X_6557_ _6630_/A _6557_/A VDD VSS sg13cmos5l_inv_1
X_5508_ _5509_/B _5382_/X _5447_/X _5859_/B1 _5448_/X VDD VSS sg13cmos5l_a22oi_1
XFILLER_10_12 VDD VSS sg13cmos5l_decap_8
X_6488_ _6837_/A _6488_/A _6835_/A VDD VSS sg13cmos5l_nand2_2
X_5439_ _5469_/A _5404_/B _5404_/A _5438_/Y VDD VSS sg13cmos5l_a21oi_1
XFILLER_59_200 VDD VSS sg13cmos5l_decap_4
X_7109_ _7109_/Y _7153_/A _7109_/B VDD VSS sg13cmos5l_nor2_1
XFILLER_59_244 VDD VSS sg13cmos5l_decap_8
XFILLER_48_929 VDD VSS sg13cmos5l_decap_4
XFILLER_74_247 VDD VSS sg13cmos5l_fill_2
XFILLER_74_225 VDD VSS sg13cmos5l_decap_8
XFILLER_74_258 VDD VSS sg13cmos5l_fill_2
XFILLER_71_932 VDD VSS sg13cmos5l_fill_2
XFILLER_35_31 VDD VSS sg13cmos5l_decap_8
XFILLER_70_442 VDD VSS sg13cmos5l_decap_8
XFILLER_43_667 VDD VSS sg13cmos5l_decap_8
XFILLER_43_656 VDD VSS sg13cmos5l_fill_2
XFILLER_51_74 VDD VSS sg13cmos5l_fill_1
XFILLER_39_929 VDD VSS sg13cmos5l_decap_4
XFILLER_65_225 VDD VSS sg13cmos5l_decap_8
XFILLER_80_206 VDD VSS sg13cmos5l_decap_8
XFILLER_62_910 VDD VSS sg13cmos5l_decap_4
X_4810_ _4817_/A _5060_/A _4810_/B VDD VSS sg13cmos5l_xnor2_1
XFILLER_61_497 VDD VSS sg13cmos5l_decap_8
X_5790_ _5825_/A _5752_/B _5752_/A _5789_/Y VDD VSS sg13cmos5l_a21oi_1
X_4741_ _4744_/A _4798_/S _4741_/B VDD VSS sg13cmos5l_xnor2_1
X_7460_ _7595_/A _7603_/A _7460_/B VDD VSS sg13cmos5l_xnor2_1
X_4672_ _4672_/Y _4672_/A _4625_/A VDD VSS sg13cmos5l_nor2b_1
X_6411_ _6421_/A _6420_/B VDD VSS sg13cmos5l_inv_1
X_7391_ _7570_/A _7349_/X _7263_/Y _7390_/Y VDD VSS sg13cmos5l_o21ai_1
X_6342_ _6346_/A _6336_/A _6342_/B VDD VSS sg13cmos5l_nand2b_2
X_6273_ _6273_/Y _6273_/A _7660_/Q _6317_/C VDD VSS sg13cmos5l_nand3_1
XFILLER_69_520 VDD VSS sg13cmos5l_decap_8
X_5224_ _5225_/B _5292_/B _5292_/A VDD VSS sg13cmos5l_xor2_1
XFILLER_69_597 VDD VSS sg13cmos5l_fill_1
X_5155_ _5156_/B _5155_/A _5218_/B VDD VSS sg13cmos5l_xor2_1
XFILLER_57_704 VDD VSS sg13cmos5l_decap_8
X_4106_ _7666_/D _4106_/A _4107_/A VDD VSS sg13cmos5l_xnor2_1
X_5086_ _5087_/B _5086_/A _5086_/B VDD VSS sg13cmos5l_xor2_1
XFILLER_112_25 VDD VSS sg13cmos5l_decap_4
X_4037_ _4037_/Y _4037_/A _4037_/B VDD VSS sg13cmos5l_nor2_1
Xbank_B_sram.gen_ihp_256x32.u_sram_256x32_507 bank_B_sram.gen_ihp_256x32.u_sram_256x32_507/L_LO
+ VDD VSS sg13cmos5l_tielo
XFILLER_71_228 VDD VSS sg13cmos5l_decap_4
Xbank_B_sram.gen_ihp_256x32.u_sram_256x32_518 bank_B_sram.gen_ihp_256x32.u_sram_256x32_518/L_LO
+ VDD VSS sg13cmos5l_tielo
Xbank_B_sram.gen_ihp_256x32.u_sram_256x32_529 bank_B_sram.gen_ihp_256x32.u_sram_256x32_529/L_LO
+ VDD VSS sg13cmos5l_tielo
XFILLER_53_932 VDD VSS sg13cmos5l_fill_2
XFILLER_65_781 VDD VSS sg13cmos5l_decap_8
XFILLER_80_740 VDD VSS sg13cmos5l_decap_4
XFILLER_52_453 VDD VSS sg13cmos5l_fill_2
XFILLER_40_615 VDD VSS sg13cmos5l_decap_4
XFILLER_52_486 VDD VSS sg13cmos5l_fill_1
X_5988_ _5992_/A _6024_/S _5988_/B VDD VSS sg13cmos5l_xnor2_1
X_4939_ _4939_/Y _4939_/A _4939_/B VDD VSS sg13cmos5l_nor2_1
X_7727_ _7727_/Q _7728_/CLK _7727_/D fanout391/X VDD VSS sg13cmos5l_dfrbpq_1
X_7658_ _7727_/D _7658_/A _7658_/B VDD VSS sg13cmos5l_nand2_2
X_6609_ _6610_/B _6607_/B _7695_/Q VDD VSS sg13cmos5l_nand2b_1
XFILLER_21_22 VDD VSS sg13cmos5l_decap_8
X_7589_ _7591_/A _7589_/A _7589_/B VDD VSS sg13cmos5l_nand2_1
XFILLER_108_4 VDD VSS sg13cmos5l_decap_8
XFILLER_79_317 VDD VSS sg13cmos5l_decap_8
XFILLER_47_203 VDD VSS sg13cmos5l_decap_4
XFILLER_75_545 VDD VSS sg13cmos5l_fill_1
XFILLER_47_236 VDD VSS sg13cmos5l_fill_1
XFILLER_48_759 VDD VSS sg13cmos5l_fill_2
XFILLER_56_781 VDD VSS sg13cmos5l_fill_1
XFILLER_71_784 VDD VSS sg13cmos5l_decap_8
XFILLER_70_250 VDD VSS sg13cmos5l_fill_2
XFILLER_70_283 VDD VSS sg13cmos5l_fill_2
XFILLER_43_497 VDD VSS sg13cmos5l_decap_8
XFILLER_79_840 VDD VSS sg13cmos5l_fill_2
XFILLER_78_383 VDD VSS sg13cmos5l_decap_8
XFILLER_38_214 VDD VSS sg13cmos5l_decap_8
X_6960_ _6960_/X _6960_/A _6960_/B VDD VSS sg13cmos5l_and2_1
XFILLER_81_526 VDD VSS sg13cmos5l_decap_8
XFILLER_35_921 VDD VSS sg13cmos5l_decap_8
XFILLER_35_932 VDD VSS sg13cmos5l_fill_2
XFILLER_47_792 VDD VSS sg13cmos5l_fill_2
XFILLER_53_217 VDD VSS sg13cmos5l_decap_4
X_5911_ _5912_/B _6085_/A _5911_/B VDD VSS sg13cmos5l_xnor2_1
X_6891_ _6891_/Y _7205_/B _6909_/B VDD VSS sg13cmos5l_nand2_1
X_5842_ _5848_/C _5843_/B _5842_/B VDD VSS sg13cmos5l_nand2b_1
XFILLER_61_294 VDD VSS sg13cmos5l_fill_2
X_5773_ _5827_/B _5773_/A _5828_/B VDD VSS sg13cmos5l_xnor2_1
X_7512_ _7621_/B _7512_/A VDD VSS sg13cmos5l_inv_1
X_4724_ _4725_/A _4724_/A _4724_/B VDD VSS sg13cmos5l_xor2_1
X_4655_ _4714_/B _4655_/A _4655_/B VDD VSS sg13cmos5l_xor2_1
X_7443_ _7496_/A _7456_/A _7443_/B VDD VSS sg13cmos5l_xnor2_1
X_4586_ _4932_/A _4586_/A VDD VSS sg13cmos5l_buf_1
X_7374_ _7507_/B _7374_/A _7374_/B VDD VSS sg13cmos5l_nand2_1
Xinput82 input82/X bank_B_we VDD VSS sg13cmos5l_buf_1
Xinput60 input60/X bank_B_wdata[19] VDD VSS sg13cmos5l_buf_1
Xinput71 input71/X bank_B_wdata[29] VDD VSS sg13cmos5l_buf_1
Xinput93 _7712_/D quant_cfg[21] VDD VSS sg13cmos5l_buf_1
X_6325_ _6328_/A _6335_/A _6335_/B VDD VSS sg13cmos5l_xnor2_1
X_6256_ _6275_/B _6256_/A VDD VSS sg13cmos5l_buf_2
X_5207_ _5207_/Y _5207_/A _5207_/B VDD VSS sg13cmos5l_nor2_1
XFILLER_69_361 VDD VSS sg13cmos5l_fill_1
XFILLER_69_350 VDD VSS sg13cmos5l_fill_1
X_6187_ _6187_/Y _6187_/A _6223_/A VDD VSS sg13cmos5l_nor2_1
X_5138_ _5138_/Y _5138_/A _5138_/B VDD VSS sg13cmos5l_nor2_1
XFILLER_69_394 VDD VSS sg13cmos5l_fill_1
XFILLER_57_534 VDD VSS sg13cmos5l_fill_2
XFILLER_57_523 VDD VSS sg13cmos5l_decap_8
XFILLER_72_537 VDD VSS sg13cmos5l_fill_1
XFILLER_72_515 VDD VSS sg13cmos5l_decap_8
XFILLER_16_11 VDD VSS sg13cmos5l_decap_8
XFILLER_44_206 VDD VSS sg13cmos5l_fill_2
X_5069_ _5088_/A _5069_/A _5069_/B VDD VSS sg13cmos5l_xor2_1
XFILLER_72_548 VDD VSS sg13cmos5l_fill_1
XFILLER_37_280 VDD VSS sg13cmos5l_decap_8
XFILLER_80_581 VDD VSS sg13cmos5l_decap_4
XFILLER_52_283 VDD VSS sg13cmos5l_decap_4
XFILLER_40_467 VDD VSS sg13cmos5l_fill_1
XFILLER_79_103 VDD VSS sg13cmos5l_decap_8
XFILLER_36_707 VDD VSS sg13cmos5l_fill_1
XFILLER_73_83 VDD VSS sg13cmos5l_decap_8
XFILLER_73_72 VDD VSS sg13cmos5l_decap_8
XFILLER_44_762 VDD VSS sg13cmos5l_fill_2
XFILLER_43_272 VDD VSS sg13cmos5l_decap_4
X_4440_ _4440_/Y _4440_/A _4440_/B VDD VSS sg13cmos5l_nor2_1
X_6110_ _6110_/Y _6110_/A _6110_/B VDD VSS sg13cmos5l_nand2_1
X_4371_ _4416_/A _4417_/B _4417_/A VDD VSS sg13cmos5l_xor2_1
X_7090_ _7249_/B _7086_/Y _7108_/S _7089_/Y VDD VSS sg13cmos5l_a21oi_1
XFILLER_79_670 VDD VSS sg13cmos5l_decap_8
XFILLER_39_501 VDD VSS sg13cmos5l_fill_2
X_6041_ _6076_/B _6128_/A _6041_/B VDD VSS sg13cmos5l_xnor2_1
XFILLER_78_180 VDD VSS sg13cmos5l_fill_2
XFILLER_39_534 VDD VSS sg13cmos5l_decap_8
XFILLER_67_887 VDD VSS sg13cmos5l_decap_8
XFILLER_81_345 VDD VSS sg13cmos5l_decap_8
X_6943_ _6943_/Y _6943_/A _6943_/B VDD VSS sg13cmos5l_nor2_1
XFILLER_35_773 VDD VSS sg13cmos5l_decap_4
X_6874_ _6874_/Y _6941_/B _6874_/B VDD VSS sg13cmos5l_nor2_1
XFILLER_62_581 VDD VSS sg13cmos5l_decap_4
X_5825_ _5826_/A _5825_/A _5849_/B VDD VSS sg13cmos5l_xnor2_1
XFILLER_50_754 VDD VSS sg13cmos5l_decap_8
XFILLER_50_776 VDD VSS sg13cmos5l_decap_8
X_5756_ _5757_/B _5643_/X _5756_/A2 _5755_/X _5756_/B2 VDD VSS sg13cmos5l_a22oi_1
X_4707_ _4708_/B _4759_/A _4759_/B VDD VSS sg13cmos5l_xor2_1
X_5687_ _5688_/B _5859_/B1 _6027_/A2 _5792_/B1 _6027_/B2 VDD VSS sg13cmos5l_a22oi_1
X_4638_ _4638_/Y _4638_/A _4638_/B VDD VSS sg13cmos5l_nor2_1
X_7426_ _7582_/A _7456_/A _7426_/B VDD VSS sg13cmos5l_xnor2_1
X_4569_ _4616_/A _4517_/B _4517_/A _4568_/X VDD VSS sg13cmos5l_a21o_1
X_7357_ _7357_/Y _7356_/Y _7394_/A2 _7377_/B VDD VSS sg13cmos5l_a21oi_1
X_6308_ _6786_/A _6308_/A _6310_/B VDD VSS sg13cmos5l_nor2b_2
X_7288_ _7289_/B _7156_/B _7276_/S _7287_/Y VDD VSS sg13cmos5l_a21oi_1
XFILLER_77_618 VDD VSS sg13cmos5l_fill_2
X_6239_ _6241_/A _6239_/A VDD VSS sg13cmos5l_buf_8
XFILLER_58_843 VDD VSS sg13cmos5l_decap_8
Xhold2086 _6198_/A _7725_/Q VDD VSS sg13cmos5l_dlygate4sd3_1
XFILLER_73_846 VDD VSS sg13cmos5l_decap_8
XFILLER_45_515 VDD VSS sg13cmos5l_decap_4
XFILLER_73_868 VDD VSS sg13cmos5l_decap_8
XFILLER_72_378 VDD VSS sg13cmos5l_decap_4
XFILLER_72_367 VDD VSS sg13cmos5l_decap_4
XFILLER_53_570 VDD VSS sg13cmos5l_fill_2
XFILLER_40_253 VDD VSS sg13cmos5l_decap_8
XFILLER_41_787 VDD VSS sg13cmos5l_decap_8
XFILLER_43_97 VDD VSS sg13cmos5l_decap_8
Xrebuffer760 _7125_/A1 rebuffer761/X VDD VSS sg13cmos5l_buf_1
Xrebuffer782 _6611_/B _6303_/A VDD VSS sg13cmos5l_buf_1
Xrebuffer771 _7437_/A2 _7110_/Y VDD VSS sg13cmos5l_buf_1
XFILLER_68_607 VDD VSS sg13cmos5l_fill_1
XFILLER_36_515 VDD VSS sg13cmos5l_decap_4
XFILLER_63_301 VDD VSS sg13cmos5l_fill_1
XFILLER_64_857 VDD VSS sg13cmos5l_decap_8
X_3940_ _4276_/A _4128_/A VDD VSS sg13cmos5l_buf_1
XFILLER_44_592 VDD VSS sg13cmos5l_decap_4
XFILLER_90_4 VDD VSS sg13cmos5l_decap_8
X_6590_ _6591_/B _6603_/A _6588_/Y _6641_/C VDD VSS sg13cmos5l_o21ai_1
X_5610_ _5613_/B _5676_/B _5670_/A VDD VSS sg13cmos5l_xnor2_1
X_5541_ _5544_/C _5541_/A _5541_/B VDD VSS sg13cmos5l_nand2_1
X_5472_ _5473_/B _5405_/A _5472_/B VDD VSS sg13cmos5l_nand2b_1
X_7211_ _7211_/Y _7211_/A _7234_/B VDD VSS sg13cmos5l_nand2_1
X_4423_ _4424_/B _3964_/C _4563_/A _3965_/B _4564_/A VDD VSS sg13cmos5l_a22oi_1
X_7142_ _7144_/A _7142_/A _7160_/A VDD VSS sg13cmos5l_nand2_1
X_4354_ _4410_/A _4411_/B _4354_/B VDD VSS sg13cmos5l_nand2_1
X_7073_ _7073_/Y _7071_/Y _7072_/Y _7030_/B VDD VSS sg13cmos5l_a21oi_1
X_4285_ _4285_/Y _4285_/A VDD VSS sg13cmos5l_inv_1
X_6024_ _6031_/A _5988_/B _5788_/A _6024_/S VDD VSS sg13cmos5l_mux2_1
XFILLER_54_312 VDD VSS sg13cmos5l_fill_1
XFILLER_39_397 VDD VSS sg13cmos5l_fill_1
XFILLER_81_142 VDD VSS sg13cmos5l_decap_8
XFILLER_70_838 VDD VSS sg13cmos5l_decap_4
X_6926_ _6985_/A _6926_/A _7059_/A VDD VSS sg13cmos5l_nand2_2
XFILLER_63_890 VDD VSS sg13cmos5l_decap_4
Xclkbuf_4_14_0_clk_i_regs clkload8/A clkbuf_0_clk_i_regs/X VDD VSS sg13cmos5l_buf_8
X_6857_ _7112_/A _7034_/A _6747_/X _6856_/X VDD VSS sg13cmos5l_a21oi_1
X_5808_ _5816_/A _5808_/A _5808_/B VDD VSS sg13cmos5l_xor2_1
X_6788_ _6788_/Y _6788_/A _6896_/B VDD VSS sg13cmos5l_nand2_1
X_5739_ _5739_/Y _5739_/A _5692_/A VDD VSS sg13cmos5l_nor2b_1
X_7409_ _7414_/A _7430_/A _7409_/B VDD VSS sg13cmos5l_nor2_1
XFILLER_77_448 VDD VSS sg13cmos5l_decap_4
XFILLER_49_117 VDD VSS sg13cmos5l_decap_8
XFILLER_38_53 VDD VSS sg13cmos5l_decap_8
XFILLER_45_312 VDD VSS sg13cmos5l_decap_4
XFILLER_58_662 VDD VSS sg13cmos5l_fill_1
XFILLER_73_654 VDD VSS sg13cmos5l_fill_1
XFILLER_72_131 VDD VSS sg13cmos5l_fill_2
XFILLER_45_334 VDD VSS sg13cmos5l_decap_4
XFILLER_57_183 VDD VSS sg13cmos5l_fill_1
XFILLER_73_665 VDD VSS sg13cmos5l_fill_1
XFILLER_72_153 VDD VSS sg13cmos5l_fill_1
XFILLER_61_849 VDD VSS sg13cmos5l_decap_8
XFILLER_54_85 VDD VSS sg13cmos5l_decap_8
XFILLER_41_573 VDD VSS sg13cmos5l_fill_1
XFILLER_70_51 VDD VSS sg13cmos5l_decap_8
Xbank_A_sram.gen_ihp_256x32.u_sram_256x32_450 bank_A_sram.gen_ihp_256x32.u_sram_256x32_450/L_LO
+ VDD VSS sg13cmos5l_tielo
Xbank_A_sram.gen_ihp_256x32.u_sram_256x32_461 bank_A_sram.gen_ihp_256x32.u_sram_256x32_461/L_LO
+ VDD VSS sg13cmos5l_tielo
X_4070_ _4312_/A _4113_/A VDD VSS sg13cmos5l_buf_1
XFILLER_76_470 VDD VSS sg13cmos5l_decap_4
XFILLER_48_161 VDD VSS sg13cmos5l_fill_1
XFILLER_49_662 VDD VSS sg13cmos5l_decap_8
XFILLER_49_684 VDD VSS sg13cmos5l_decap_8
XFILLER_64_610 VDD VSS sg13cmos5l_decap_8
XFILLER_36_312 VDD VSS sg13cmos5l_decap_8
XFILLER_48_183 VDD VSS sg13cmos5l_fill_1
XFILLER_63_120 VDD VSS sg13cmos5l_fill_1
XFILLER_37_879 VDD VSS sg13cmos5l_decap_8
XFILLER_52_816 VDD VSS sg13cmos5l_decap_8
X_4972_ _4973_/A _4972_/A _4972_/B VDD VSS sg13cmos5l_xor2_1
X_7691_ _7691_/Q _7691_/CLK _7691_/D fanout385/X VDD VSS sg13cmos5l_dfrbpq_1
X_6711_ _6711_/X _6941_/B VDD VSS sg13cmos5l_buf_4
X_6642_ _6732_/A _6642_/A _6734_/B VDD VSS sg13cmos5l_nor2b_1
X_6573_ _6770_/B _6573_/A _6573_/B _6860_/A VDD VSS sg13cmos5l_nand3_1
X_5524_ _5525_/B _5579_/B _5579_/A VDD VSS sg13cmos5l_xor2_1
X_5455_ _5456_/B _5572_/A _5756_/A2 _5505_/A _5756_/B2 VDD VSS sg13cmos5l_a22oi_1
X_4406_ _4407_/B _4414_/B _4414_/A VDD VSS sg13cmos5l_xor2_1
Xfanout203 _5644_/B2 _5082_/X VDD VSS sg13cmos5l_buf_1
X_7125_ _7125_/Y _7125_/A1 _7125_/A2 _7134_/B VDD VSS sg13cmos5l_a21oi_1
XFILLER_59_404 VDD VSS sg13cmos5l_decap_8
X_5386_ _5434_/B _5446_/A _5386_/B VDD VSS sg13cmos5l_xnor2_1
Xfanout214 _5943_/A2 _5447_/X VDD VSS sg13cmos5l_buf_1
Xfanout225 _5081_/A _4529_/X VDD VSS sg13cmos5l_buf_1
Xfanout236 _6128_/A _6168_/A VDD VSS sg13cmos5l_buf_1
Xfanout247 _4752_/A _4076_/X VDD VSS sg13cmos5l_buf_1
X_4337_ _4337_/Y _4337_/A _4337_/B VDD VSS sg13cmos5l_nand2_1
Xfanout269 _5586_/A _5400_/A VDD VSS sg13cmos5l_buf_1
Xfanout258 _7071_/B _6995_/X VDD VSS sg13cmos5l_buf_1
X_7056_ _7057_/B _7191_/A _7055_/X _7080_/A VDD VSS sg13cmos5l_mux2_1
XFILLER_59_459 VDD VSS sg13cmos5l_decap_8
X_4268_ _4337_/B _4268_/A _4268_/B VDD VSS sg13cmos5l_xor2_1
XFILLER_74_407 VDD VSS sg13cmos5l_decap_8
X_6007_ _6007_/Y _6007_/A _6007_/B _6007_/C VDD VSS sg13cmos5l_nand3_1
X_4199_ _6053_/B _4266_/A _4200_/B VDD VSS sg13cmos5l_nor2_1
XFILLER_82_462 VDD VSS sg13cmos5l_fill_2
XFILLER_70_624 VDD VSS sg13cmos5l_fill_2
XFILLER_42_337 VDD VSS sg13cmos5l_decap_8
XFILLER_54_197 VDD VSS sg13cmos5l_decap_8
X_6909_ _6925_/A _6909_/A _6909_/B _7225_/C VDD VSS sg13cmos5l_nand3_1
XFILLER_40_76 VDD VSS sg13cmos5l_decap_8
XFILLER_78_746 VDD VSS sg13cmos5l_decap_4
XFILLER_66_919 VDD VSS sg13cmos5l_fill_2
XFILLER_37_109 VDD VSS sg13cmos5l_decap_8
XFILLER_1_26 VDD VSS sg13cmos5l_fill_2
XFILLER_65_407 VDD VSS sg13cmos5l_fill_2
XFILLER_45_131 VDD VSS sg13cmos5l_decap_8
XFILLER_46_676 VDD VSS sg13cmos5l_decap_8
XFILLER_60_101 VDD VSS sg13cmos5l_decap_8
XFILLER_61_646 VDD VSS sg13cmos5l_decap_4
XFILLER_61_635 VDD VSS sg13cmos5l_fill_2
XFILLER_60_156 VDD VSS sg13cmos5l_decap_4
X_5240_ _5240_/Y _5240_/A _5184_/A VDD VSS sg13cmos5l_nor2b_1
X_5171_ _5227_/A _5781_/A _5171_/B VDD VSS sg13cmos5l_nor2_1
X_4122_ _4122_/X _4122_/A VDD VSS sg13cmos5l_buf_1
X_4053_ _4063_/A _4168_/A _4053_/B VDD VSS sg13cmos5l_xnor2_1
XFILLER_68_278 VDD VSS sg13cmos5l_fill_2
Xinput3 input3/X bank_A_addr[2] VDD VSS sg13cmos5l_buf_1
XFILLER_52_602 VDD VSS sg13cmos5l_decap_4
XFILLER_64_462 VDD VSS sg13cmos5l_decap_8
XFILLER_36_186 VDD VSS sg13cmos5l_decap_8
XFILLER_52_613 VDD VSS sg13cmos5l_fill_2
XFILLER_52_635 VDD VSS sg13cmos5l_decap_8
XFILLER_52_668 VDD VSS sg13cmos5l_fill_1
X_4955_ _5026_/B _4955_/A _4955_/B VDD VSS sg13cmos5l_xor2_1
X_4886_ _5257_/A _4886_/A VDD VSS sg13cmos5l_buf_1
X_7674_ _7674_/Q _7675_/CLK _7674_/D fanout387/X VDD VSS sg13cmos5l_dfrbpq_1
X_6625_ _6626_/B _6622_/Y _6632_/A _6641_/C VDD VSS sg13cmos5l_o21ai_1
X_6556_ _6557_/A _6982_/A _7274_/A VDD VSS sg13cmos5l_nor2_1
X_5507_ _5561_/A _5870_/A _5507_/B VDD VSS sg13cmos5l_xnor2_1
X_6487_ _6835_/A _7681_/Q _6487_/B VDD VSS sg13cmos5l_xnor2_1
X_5438_ _5438_/Y _5438_/A _5403_/B VDD VSS sg13cmos5l_nor2b_1
X_5369_ _5377_/A _5044_/A _5368_/A _5368_/Y VDD VSS sg13cmos5l_a21oi_1
XFILLER_59_212 VDD VSS sg13cmos5l_decap_4
X_7108_ _7109_/B _6762_/Y _6751_/A _7108_/S VDD VSS sg13cmos5l_mux2_1
XFILLER_48_919 VDD VSS sg13cmos5l_fill_1
XFILLER_74_204 VDD VSS sg13cmos5l_decap_8
X_7039_ _7327_/B _7031_/Y _7076_/B _7038_/X VDD VSS sg13cmos5l_a21oi_1
XFILLER_71_900 VDD VSS sg13cmos5l_decap_4
XFILLER_43_602 VDD VSS sg13cmos5l_fill_2
XFILLER_42_101 VDD VSS sg13cmos5l_decap_8
XFILLER_43_635 VDD VSS sg13cmos5l_decap_8
XFILLER_70_432 VDD VSS sg13cmos5l_decap_4
XFILLER_42_145 VDD VSS sg13cmos5l_fill_2
XFILLER_70_476 VDD VSS sg13cmos5l_fill_1
XFILLER_35_87 VDD VSS sg13cmos5l_decap_4
XFILLER_51_20 VDD VSS sg13cmos5l_fill_1
XFILLER_51_53 VDD VSS sg13cmos5l_fill_2
XFILLER_51_42 VDD VSS sg13cmos5l_fill_2
XFILLER_39_908 VDD VSS sg13cmos5l_decap_8
XFILLER_25_8 VDD VSS sg13cmos5l_decap_8
XFILLER_59_790 VDD VSS sg13cmos5l_decap_8
XFILLER_65_248 VDD VSS sg13cmos5l_fill_1
XFILLER_73_270 VDD VSS sg13cmos5l_fill_2
XFILLER_46_473 VDD VSS sg13cmos5l_decap_4
XFILLER_62_933 VDD VSS sg13cmos5l_fill_1
XFILLER_73_292 VDD VSS sg13cmos5l_decap_8
XFILLER_61_476 VDD VSS sg13cmos5l_decap_8
XFILLER_61_465 VDD VSS sg13cmos5l_fill_2
X_4740_ _4741_/B _5245_/A _4740_/B VDD VSS sg13cmos5l_xnor2_1
X_4671_ _4724_/A _4671_/A _4671_/B VDD VSS sg13cmos5l_nor2_1
X_7390_ _7390_/Y _7268_/Y _7313_/X _7343_/X VDD VSS sg13cmos5l_a21oi_1
X_6410_ _6420_/B _6410_/A _6410_/B VDD VSS sg13cmos5l_nand2_2
X_6341_ _6811_/B _6341_/A _6341_/B VDD VSS sg13cmos5l_nand2_2
X_6272_ _6328_/C _6275_/B VDD VSS sg13cmos5l_buf_2
X_5223_ _5292_/A _5160_/B _5160_/A _5222_/Y VDD VSS sg13cmos5l_a21o_1
X_5154_ _5218_/B _5154_/A _5154_/B VDD VSS sg13cmos5l_xor2_1
X_4105_ _4107_/A _6182_/A _4103_/Y _4104_/Y VDD VSS sg13cmos5l_a21oi_2
X_5085_ _5086_/B _5138_/A _5138_/B VDD VSS sg13cmos5l_xor2_1
XFILLER_57_749 VDD VSS sg13cmos5l_decap_8
X_4036_ _4067_/A _4042_/B _4036_/B VDD VSS sg13cmos5l_xor2_1
XFILLER_72_719 VDD VSS sg13cmos5l_decap_8
XFILLER_37_451 VDD VSS sg13cmos5l_fill_1
XFILLER_56_248 VDD VSS sg13cmos5l_fill_2
XFILLER_71_207 VDD VSS sg13cmos5l_decap_8
Xbank_B_sram.gen_ihp_256x32.u_sram_256x32_508 bank_B_sram.gen_ihp_256x32.u_sram_256x32_508/L_LO
+ VDD VSS sg13cmos5l_tielo
Xbank_B_sram.gen_ihp_256x32.u_sram_256x32_519 bank_B_sram.gen_ihp_256x32.u_sram_256x32_519/L_LO
+ VDD VSS sg13cmos5l_tielo
XFILLER_52_432 VDD VSS sg13cmos5l_decap_8
XFILLER_64_292 VDD VSS sg13cmos5l_decap_4
X_5987_ _5988_/B _6085_/A _5987_/B VDD VSS sg13cmos5l_xnor2_1
X_7726_ _7726_/Q _7728_/CLK _7726_/D fanout391/X VDD VSS sg13cmos5l_dfrbpq_1
X_4938_ _4955_/A _4938_/A _4938_/B VDD VSS sg13cmos5l_xor2_1
X_7657_ _7658_/A _7657_/A _7657_/B VDD VSS sg13cmos5l_nand2_2
XANTENNA_30 _6191_/Y VDD VSS sg13cmos5l_antennanp
X_4869_ _4870_/B _4631_/X _4996_/A _5117_/B1 _4997_/A VDD VSS sg13cmos5l_a22oi_1
X_6608_ _6610_/A _6757_/B _6757_/A VDD VSS sg13cmos5l_nand2_2
X_7588_ _7592_/B _7588_/A _7625_/A VDD VSS sg13cmos5l_nand2_2
X_6539_ _6547_/A _6539_/A _6873_/A VDD VSS sg13cmos5l_nand2_2
Xoutput170 bank_B_rdata[2] _6217_/B VDD VSS sg13cmos5l_buf_1
XFILLER_48_727 VDD VSS sg13cmos5l_fill_1
XFILLER_47_259 VDD VSS sg13cmos5l_fill_1
XFILLER_46_64 VDD VSS sg13cmos5l_fill_1
XFILLER_62_30 VDD VSS sg13cmos5l_fill_2
XFILLER_62_96 VDD VSS sg13cmos5l_decap_4
XFILLER_79_852 VDD VSS sg13cmos5l_fill_2
XFILLER_79_896 VDD VSS sg13cmos5l_fill_1
XFILLER_78_395 VDD VSS sg13cmos5l_decap_8
XFILLER_16_4 VDD VSS sg13cmos5l_decap_8
XFILLER_81_505 VDD VSS sg13cmos5l_decap_8
XFILLER_66_557 VDD VSS sg13cmos5l_decap_8
XFILLER_47_760 VDD VSS sg13cmos5l_fill_1
X_5910_ _5911_/B _6026_/B1 _6027_/A2 _5985_/B1 _6027_/B2 VDD VSS sg13cmos5l_a22oi_1
X_6890_ _7205_/B _6890_/A VDD VSS sg13cmos5l_inv_1
XFILLER_62_730 VDD VSS sg13cmos5l_fill_1
X_5841_ _5842_/B _6042_/A _5780_/B _5840_/Y VDD VSS sg13cmos5l_o21ai_1
X_5772_ _5828_/B _5772_/A _5772_/B VDD VSS sg13cmos5l_xnor2_1
X_7511_ _7512_/A _7511_/A _7511_/B VDD VSS sg13cmos5l_xor2_1
X_4723_ _4724_/B _4785_/B _4785_/A VDD VSS sg13cmos5l_xor2_1
X_7442_ _7443_/B _7472_/A1 _7157_/Y _7472_/B1 VDD VSS sg13cmos5l_o21ai_1
X_4654_ _4655_/B _4684_/A _4654_/B VDD VSS sg13cmos5l_xnor2_1
X_4585_ _4585_/X _4647_/B VDD VSS sg13cmos5l_buf_1
X_7373_ _7506_/B _7373_/A _7424_/A VDD VSS sg13cmos5l_nand2_1
Xinput61 input61/X bank_B_wdata[1] VDD VSS sg13cmos5l_buf_1
Xinput72 input72/X bank_B_wdata[2] VDD VSS sg13cmos5l_buf_1
Xinput50 input50/X bank_B_wdata[0] VDD VSS sg13cmos5l_buf_1
Xinput94 _7713_/D quant_cfg[22] VDD VSS sg13cmos5l_buf_1
Xinput83 _4200_/B quant_cfg[10] VDD VSS sg13cmos5l_buf_1
X_6324_ _6335_/B _6324_/A _6324_/B VDD VSS sg13cmos5l_nand2_2
XFILLER_107_15 VDD VSS sg13cmos5l_decap_8
X_6255_ _6256_/A _6977_/B _6785_/A _6979_/B _6290_/C VDD VSS sg13cmos5l_nand4_1
X_5206_ _5207_/B _5206_/A _5206_/B _5206_/C VDD VSS sg13cmos5l_nor3_1
X_6186_ _6227_/A _6212_/A VDD VSS sg13cmos5l_buf_1
X_5137_ _5154_/A _5137_/A _5137_/B VDD VSS sg13cmos5l_xor2_1
XFILLER_45_708 VDD VSS sg13cmos5l_fill_1
X_5068_ _5069_/B _5123_/A _5123_/B VDD VSS sg13cmos5l_xor2_1
X_4019_ _4020_/B _3937_/A _3998_/A _3999_/B _4122_/A VDD VSS sg13cmos5l_a22oi_1
XFILLER_80_560 VDD VSS sg13cmos5l_decap_8
XFILLER_52_240 VDD VSS sg13cmos5l_decap_4
X_7709_ _7709_/Q _7719_/CLK _7709_/D fanout389/X VDD VSS sg13cmos5l_dfrbpq_1
XFILLER_76_855 VDD VSS sg13cmos5l_fill_1
XFILLER_48_568 VDD VSS sg13cmos5l_fill_1
XFILLER_75_387 VDD VSS sg13cmos5l_fill_1
XFILLER_35_218 VDD VSS sg13cmos5l_decap_4
XFILLER_43_284 VDD VSS sg13cmos5l_decap_4
X_4370_ _4417_/A _4318_/B _4318_/A _4369_/X VDD VSS sg13cmos5l_a21o_1
X_6040_ _6041_/B _6073_/B _6073_/A VDD VSS sg13cmos5l_xnor2_1
XFILLER_66_321 VDD VSS sg13cmos5l_fill_2
XFILLER_78_192 VDD VSS sg13cmos5l_decap_8
XFILLER_39_568 VDD VSS sg13cmos5l_fill_2
XFILLER_39_546 VDD VSS sg13cmos5l_decap_8
XFILLER_81_324 VDD VSS sg13cmos5l_decap_8
XFILLER_35_730 VDD VSS sg13cmos5l_fill_1
X_6942_ _6943_/B _6970_/B _6841_/X _6941_/Y VDD VSS sg13cmos5l_o21ai_1
X_6873_ _6874_/B _6873_/A _6873_/B VDD VSS sg13cmos5l_xnor2_1
XFILLER_35_763 VDD VSS sg13cmos5l_decap_4
XFILLER_50_733 VDD VSS sg13cmos5l_decap_8
X_5824_ _5849_/B _5850_/B _5824_/B VDD VSS sg13cmos5l_xnor2_1
X_5755_ _5755_/X _5755_/A VDD VSS sg13cmos5l_buf_1
X_4706_ _4759_/B _4771_/A _4706_/B VDD VSS sg13cmos5l_xnor2_1
X_5686_ _5686_/X _5686_/A VDD VSS sg13cmos5l_buf_1
X_4637_ _4655_/A _4637_/A _4637_/B VDD VSS sg13cmos5l_xor2_1
X_7425_ _7426_/B _7472_/A1 _7425_/A2 _7472_/B1 VDD VSS sg13cmos5l_o21ai_1
X_7356_ _7356_/Y _7356_/A VDD VSS sg13cmos5l_inv_1
X_4568_ _4568_/X _4568_/A _4568_/B VDD VSS sg13cmos5l_and2_1
X_6307_ _6310_/B _6307_/A _7663_/Q _6317_/C VDD VSS sg13cmos5l_nand3_1
X_7287_ _7287_/Y _7163_/A _7163_/C _7276_/S VDD VSS sg13cmos5l_a21oi_1
X_4499_ _4503_/B _4560_/A _4560_/B VDD VSS sg13cmos5l_xnor2_1
X_6238_ _6239_/A _6244_/A _6254_/A _6242_/A VDD VSS sg13cmos5l_nand3_1
X_6169_ _6172_/A _6178_/A _6169_/B VDD VSS sg13cmos5l_xnor2_1
XFILLER_58_833 VDD VSS sg13cmos5l_fill_1
XFILLER_69_192 VDD VSS sg13cmos5l_decap_4
Xhold2087 _6200_/A2 _6198_/Y VDD VSS sg13cmos5l_dlygate4sd3_1
XFILLER_57_354 VDD VSS sg13cmos5l_fill_1
XFILLER_72_302 VDD VSS sg13cmos5l_fill_2
XFILLER_27_22 VDD VSS sg13cmos5l_decap_8
XFILLER_57_376 VDD VSS sg13cmos5l_decap_8
XFILLER_58_888 VDD VSS sg13cmos5l_decap_8
XFILLER_58_899 VDD VSS sg13cmos5l_fill_2
XFILLER_72_324 VDD VSS sg13cmos5l_fill_1
XFILLER_60_508 VDD VSS sg13cmos5l_decap_4
XFILLER_41_711 VDD VSS sg13cmos5l_decap_8
XFILLER_41_766 VDD VSS sg13cmos5l_fill_2
XFILLER_41_755 VDD VSS sg13cmos5l_fill_1
XFILLER_40_232 VDD VSS sg13cmos5l_decap_8
XFILLER_40_276 VDD VSS sg13cmos5l_fill_2
XFILLER_43_76 VDD VSS sg13cmos5l_decap_8
Xrebuffer750 rebuffer750/X rebuffer751/X VDD VSS sg13cmos5l_buf_1
Xrebuffer772 _6812_/B _6363_/A VDD VSS sg13cmos5l_buf_1
Xrebuffer783 _7501_/A _7408_/A VDD VSS sg13cmos5l_buf_1
Xrebuffer761 rebuffer761/X rebuffer762/X VDD VSS sg13cmos5l_buf_1
XFILLER_49_800 VDD VSS sg13cmos5l_fill_1
XFILLER_48_310 VDD VSS sg13cmos5l_decap_8
XFILLER_49_844 VDD VSS sg13cmos5l_fill_2
XFILLER_75_195 VDD VSS sg13cmos5l_decap_4
X_5540_ _5544_/A _5608_/B VDD VSS sg13cmos5l_inv_1
X_5471_ _5473_/A _5406_/B _5471_/B VDD VSS sg13cmos5l_nand2b_1
X_7210_ _7211_/A _7210_/A _7248_/A _7210_/C VDD VSS sg13cmos5l_nand3_1
X_4422_ _4489_/B _4422_/A _4495_/A VDD VSS sg13cmos5l_nor2_1
X_7141_ _7141_/Y _7189_/A _7141_/B VDD VSS sg13cmos5l_nor2_1
X_4353_ _7671_/D _4353_/A _4353_/B VDD VSS sg13cmos5l_xor2_1
X_7072_ _7072_/Y _7072_/A _7072_/B VDD VSS sg13cmos5l_nand2_1
X_4284_ _4297_/B _4337_/A _4337_/B VDD VSS sg13cmos5l_xor2_1
X_6023_ _6032_/A _6025_/B _6057_/B VDD VSS sg13cmos5l_xnor2_1
XFILLER_58_118 VDD VSS sg13cmos5l_fill_2
XFILLER_67_663 VDD VSS sg13cmos5l_fill_2
XFILLER_39_365 VDD VSS sg13cmos5l_fill_2
XFILLER_55_836 VDD VSS sg13cmos5l_decap_8
XFILLER_82_633 VDD VSS sg13cmos5l_decap_4
XFILLER_82_622 VDD VSS sg13cmos5l_decap_8
XFILLER_81_121 VDD VSS sg13cmos5l_decap_8
XFILLER_55_858 VDD VSS sg13cmos5l_fill_2
XFILLER_66_195 VDD VSS sg13cmos5l_fill_1
XFILLER_42_508 VDD VSS sg13cmos5l_decap_8
X_6925_ _6926_/A _6925_/A _7111_/A _7318_/B VDD VSS sg13cmos5l_nand3_1
XFILLER_81_198 VDD VSS sg13cmos5l_decap_8
X_6856_ _6856_/X _7012_/A _7021_/A VDD VSS sg13cmos5l_and2_1
X_3999_ _4000_/B _4640_/A _3999_/B VDD VSS sg13cmos5l_nand2_1
X_6787_ _6788_/A _6787_/A _6787_/B VDD VSS sg13cmos5l_xnor2_1
X_5807_ _5808_/B _5863_/A _5863_/B VDD VSS sg13cmos5l_xor2_1
X_5738_ _5840_/B _5738_/A _5727_/A VDD VSS sg13cmos5l_nor2b_1
X_5669_ _5733_/B _5781_/A _5676_/A VDD VSS sg13cmos5l_xnor2_1
X_7408_ _7415_/A _7408_/A _7408_/B _7500_/A VDD VSS sg13cmos5l_nand3_1
X_7339_ _7347_/A _7327_/A _7104_/Y _7338_/Y VDD VSS sg13cmos5l_o21ai_1
XFILLER_38_32 VDD VSS sg13cmos5l_decap_8
XFILLER_46_825 VDD VSS sg13cmos5l_fill_1
XFILLER_45_346 VDD VSS sg13cmos5l_fill_1
XFILLER_45_357 VDD VSS sg13cmos5l_fill_1
XFILLER_61_828 VDD VSS sg13cmos5l_decap_8
XFILLER_72_187 VDD VSS sg13cmos5l_fill_1
XFILLER_54_42 VDD VSS sg13cmos5l_decap_8
XFILLER_69_917 VDD VSS sg13cmos5l_fill_2
Xbank_A_sram.gen_ihp_256x32.u_sram_256x32_440 bank_A_sram.gen_ihp_256x32.u_sram_256x32_440/L_LO
+ VDD VSS sg13cmos5l_tielo
Xbank_A_sram.gen_ihp_256x32.u_sram_256x32_451 bank_A_sram.gen_ihp_256x32.u_sram_256x32_451/L_LO
+ VDD VSS sg13cmos5l_tielo
Xbank_A_sram.gen_ihp_256x32.u_sram_256x32_462 bank_A_sram.gen_ihp_256x32.u_sram_256x32_462/L_LO
+ VDD VSS sg13cmos5l_tielo
XFILLER_37_858 VDD VSS sg13cmos5l_decap_8
XFILLER_64_655 VDD VSS sg13cmos5l_fill_1
XFILLER_64_666 VDD VSS sg13cmos5l_decap_8
X_4971_ _4972_/B _5035_/B _5035_/A VDD VSS sg13cmos5l_xor2_1
XFILLER_45_880 VDD VSS sg13cmos5l_decap_4
X_7690_ _7690_/Q _7691_/CLK _7690_/D fanout385/X VDD VSS sg13cmos5l_dfrbpq_1
X_6710_ _6970_/B _6915_/A VDD VSS sg13cmos5l_buf_1
XFILLER_60_850 VDD VSS sg13cmos5l_fill_1
X_6641_ _6734_/B _6641_/A _7699_/Q _6641_/C VDD VSS sg13cmos5l_nand3_1
X_6572_ _6860_/A _6572_/A VDD VSS sg13cmos5l_buf_1
X_5523_ _5579_/A _5645_/A _5523_/B VDD VSS sg13cmos5l_xnor2_1
X_5454_ _5501_/A _5402_/B _5402_/A _5453_/Y VDD VSS sg13cmos5l_a21oi_1
X_4405_ _4414_/A _4340_/B _4340_/A _4404_/X VDD VSS sg13cmos5l_a21o_1
X_5385_ _5386_/B _5257_/X _5447_/A _5745_/B1 _5448_/A VDD VSS sg13cmos5l_a22oi_1
Xfanout204 _5644_/A2 _5081_/X VDD VSS sg13cmos5l_buf_1
X_4336_ _4336_/Y _4336_/A VDD VSS sg13cmos5l_inv_1
X_7124_ _7176_/B _7718_/Q VDD VSS sg13cmos5l_inv_1
XFILLER_115_15 VDD VSS sg13cmos5l_decap_8
Xfanout237 _5685_/A _5118_/X VDD VSS sg13cmos5l_buf_1
Xfanout215 _5858_/A _5309_/X VDD VSS sg13cmos5l_buf_1
Xfanout226 _7464_/B _7585_/A VDD VSS sg13cmos5l_buf_1
X_7055_ _7055_/X _6906_/B _7071_/B _7054_/X VDD VSS sg13cmos5l_a21o_1
Xfanout259 _7080_/A _7067_/A VDD VSS sg13cmos5l_buf_1
Xfanout248 _4751_/A _4047_/X VDD VSS sg13cmos5l_buf_1
X_4267_ _4268_/B _4305_/A _4305_/B VDD VSS sg13cmos5l_xor2_1
X_6006_ _6008_/A _6007_/A _6007_/C _6007_/B VDD VSS sg13cmos5l_a21oi_1
XFILLER_55_611 VDD VSS sg13cmos5l_decap_8
X_4198_ _6022_/A _4508_/A VDD VSS sg13cmos5l_inv_1
XFILLER_39_195 VDD VSS sg13cmos5l_fill_2
XFILLER_54_110 VDD VSS sg13cmos5l_fill_1
XFILLER_55_655 VDD VSS sg13cmos5l_fill_2
XFILLER_55_699 VDD VSS sg13cmos5l_decap_4
XFILLER_24_23 VDD VSS sg13cmos5l_decap_4
X_6908_ _7225_/C _7127_/A _6908_/B VDD VSS sg13cmos5l_nand2_1
X_6839_ _6839_/Y _6939_/B _6896_/B VDD VSS sg13cmos5l_nand2_1
XFILLER_50_382 VDD VSS sg13cmos5l_fill_2
XFILLER_51_894 VDD VSS sg13cmos5l_fill_1
XFILLER_40_22 VDD VSS sg13cmos5l_decap_8
XFILLER_40_55 VDD VSS sg13cmos5l_decap_8
XFILLER_78_725 VDD VSS sg13cmos5l_decap_8
XFILLER_49_97 VDD VSS sg13cmos5l_decap_8
XFILLER_73_474 VDD VSS sg13cmos5l_fill_2
XFILLER_60_135 VDD VSS sg13cmos5l_decap_8
XFILLER_42_872 VDD VSS sg13cmos5l_fill_1
XFILLER_60_179 VDD VSS sg13cmos5l_decap_8
XFILLER_81_73 VDD VSS sg13cmos5l_fill_2
X_5170_ _7684_/D _5170_/A _5170_/B VDD VSS sg13cmos5l_xor2_1
X_4121_ _4135_/A _4121_/A1 _4092_/A _4120_/Y VDD VSS sg13cmos5l_a21oi_1
X_4052_ _4053_/B _3963_/A _3998_/A _3937_/A _4122_/A VDD VSS sg13cmos5l_a22oi_1
XFILLER_68_257 VDD VSS sg13cmos5l_decap_8
Xinput4 input4/X bank_A_addr[3] VDD VSS sg13cmos5l_buf_1
XFILLER_65_931 VDD VSS sg13cmos5l_fill_2
XFILLER_37_655 VDD VSS sg13cmos5l_fill_1
XFILLER_36_165 VDD VSS sg13cmos5l_decap_8
XFILLER_64_485 VDD VSS sg13cmos5l_decap_4
X_4954_ _4955_/B _4994_/A _4954_/B VDD VSS sg13cmos5l_xnor2_1
XFILLER_40_809 VDD VSS sg13cmos5l_fill_1
X_4885_ _4895_/A _5331_/A _4885_/B VDD VSS sg13cmos5l_xnor2_1
X_7673_ _7673_/Q _7675_/CLK _7673_/D fanout387/X VDD VSS sg13cmos5l_dfrbpq_1
X_6624_ _6632_/A _6631_/B _6631_/C VDD VSS sg13cmos5l_nor2_1
X_6555_ _6564_/A _6555_/A _6555_/B _6869_/B VDD VSS sg13cmos5l_nand3_1
X_5506_ _5507_/B _5985_/B1 _5869_/A2 _5443_/X _5869_/B2 VDD VSS sg13cmos5l_a22oi_1
X_6486_ _6487_/B _6491_/A _6485_/Y _6459_/X VDD VSS sg13cmos5l_o21ai_1
X_5437_ _5530_/B _5437_/A _5437_/B VDD VSS sg13cmos5l_xor2_1
XFILLER_86_18 VDD VSS sg13cmos5l_decap_8
X_5368_ _5368_/Y _5368_/A _5368_/B VDD VSS sg13cmos5l_nor2_1
X_4319_ _4319_/Y _4319_/A _4319_/B VDD VSS sg13cmos5l_nor2_1
X_5299_ _5360_/A _5299_/A _5233_/B VDD VSS sg13cmos5l_nor2b_2
X_7107_ _7107_/Y _7108_/S _7106_/Y _7126_/B VDD VSS sg13cmos5l_o21ai_1
XFILLER_75_717 VDD VSS sg13cmos5l_decap_8
X_7038_ _7038_/X _7038_/A _7038_/B VDD VSS sg13cmos5l_and2_1
XFILLER_74_249 VDD VSS sg13cmos5l_fill_1
XFILLER_70_411 VDD VSS sg13cmos5l_decap_4
XFILLER_82_293 VDD VSS sg13cmos5l_fill_1
XFILLER_43_658 VDD VSS sg13cmos5l_fill_1
XFILLER_78_555 VDD VSS sg13cmos5l_decap_8
XFILLER_78_566 VDD VSS sg13cmos5l_fill_1
XFILLER_76_73 VDD VSS sg13cmos5l_decap_8
XFILLER_74_783 VDD VSS sg13cmos5l_decap_8
X_4670_ _7676_/D _4727_/B _4727_/A VDD VSS sg13cmos5l_xor2_1
X_6340_ _6341_/A _6790_/B _6790_/A VDD VSS sg13cmos5l_nand2_2
X_6271_ _6804_/A _6273_/A _6275_/B _7660_/Q VDD VSS sg13cmos5l_a21oi_1
X_5222_ _5222_/Y _5222_/A _5161_/B VDD VSS sg13cmos5l_nor2b_1
X_5153_ _5154_/B _5186_/A _5153_/B VDD VSS sg13cmos5l_xnor2_1
X_4104_ _4104_/Y _6181_/B _6181_/A VDD VSS sg13cmos5l_nor2_1
XFILLER_69_566 VDD VSS sg13cmos5l_fill_1
XFILLER_69_555 VDD VSS sg13cmos5l_fill_1
X_5084_ _5138_/B _5586_/A _5084_/B VDD VSS sg13cmos5l_xnor2_1
XFILLER_38_920 VDD VSS sg13cmos5l_decap_8
X_4035_ _4036_/B _4033_/Y _4009_/A _4034_/Y VDD VSS sg13cmos5l_a21oi_1
XFILLER_65_750 VDD VSS sg13cmos5l_fill_1
Xbank_B_sram.gen_ihp_256x32.u_sram_256x32_509 bank_B_sram.gen_ihp_256x32.u_sram_256x32_509/L_LO
+ VDD VSS sg13cmos5l_tielo
XFILLER_52_466 VDD VSS sg13cmos5l_fill_1
X_5986_ _5987_/B _6082_/B1 _6027_/A2 _6058_/B1 _6027_/B2 VDD VSS sg13cmos5l_a22oi_1
X_7725_ _7725_/Q clkload3/A _7725_/D fanout382/X VDD VSS sg13cmos5l_dfrbpq_1
X_4937_ _4938_/B _4990_/A _4990_/B VDD VSS sg13cmos5l_xor2_1
XANTENNA_20 input65/X VDD VSS sg13cmos5l_antennanp
X_7656_ _7657_/B _7656_/A _7537_/A VDD VSS sg13cmos5l_nor2b_1
X_4868_ _4898_/A _4834_/B _4834_/A _4867_/Y VDD VSS sg13cmos5l_a21oi_1
X_6607_ _6757_/A _7695_/Q _6607_/B VDD VSS sg13cmos5l_xnor2_1
X_4799_ _4858_/S _4859_/B1 _5309_/A _4799_/B1 _4561_/X VDD VSS sg13cmos5l_a22oi_1
X_7587_ _7625_/A _7587_/A _7587_/B VDD VSS sg13cmos5l_xnor2_1
X_6538_ _6873_/A _6538_/A _6870_/B VDD VSS sg13cmos5l_nor2b_1
XFILLER_97_28 VDD VSS sg13cmos5l_fill_1
X_6469_ _6470_/B _6476_/A _6468_/X _6527_/A VDD VSS sg13cmos5l_o21ai_1
Xoutput160 bank_B_rdata[20] output160/A VDD VSS sg13cmos5l_buf_1
Xoutput171 bank_B_rdata[30] output171/A VDD VSS sg13cmos5l_buf_1
XFILLER_75_536 VDD VSS sg13cmos5l_decap_8
XFILLER_47_227 VDD VSS sg13cmos5l_decap_8
XFILLER_46_43 VDD VSS sg13cmos5l_decap_8
XFILLER_56_750 VDD VSS sg13cmos5l_fill_1
XFILLER_46_76 VDD VSS sg13cmos5l_decap_8
XFILLER_62_219 VDD VSS sg13cmos5l_decap_4
XFILLER_71_753 VDD VSS sg13cmos5l_fill_1
XFILLER_46_87 VDD VSS sg13cmos5l_fill_1
XFILLER_70_285 VDD VSS sg13cmos5l_fill_1
XFILLER_7_15 VDD VSS sg13cmos5l_decap_8
XFILLER_39_728 VDD VSS sg13cmos5l_decap_8
XFILLER_38_249 VDD VSS sg13cmos5l_decap_8
XFILLER_62_742 VDD VSS sg13cmos5l_decap_4
X_5840_ _5840_/Y _5840_/A _5840_/B VDD VSS sg13cmos5l_nand2_1
X_5771_ _5772_/B _5822_/A _5822_/B VDD VSS sg13cmos5l_xnor2_1
XFILLER_61_263 VDD VSS sg13cmos5l_decap_4
XFILLER_62_797 VDD VSS sg13cmos5l_decap_8
X_7510_ _7511_/B _7510_/A _7510_/B VDD VSS sg13cmos5l_nand2_1
X_4722_ _4785_/A _4665_/B _4665_/A _4721_/X VDD VSS sg13cmos5l_a21o_1
X_7441_ _7444_/A _7441_/A _7441_/B VDD VSS sg13cmos5l_nand2_2
X_4653_ _4654_/B _4653_/A _4653_/B VDD VSS sg13cmos5l_xor2_1
Xinput40 input40/X bank_A_wdata[9] VDD VSS sg13cmos5l_buf_1
X_7372_ _7387_/A _7374_/B VDD VSS sg13cmos5l_buf_4
X_4584_ _4595_/A _4761_/A _4584_/B VDD VSS sg13cmos5l_xnor2_1
Xinput51 input51/X bank_B_wdata[10] VDD VSS sg13cmos5l_buf_1
Xinput62 input62/X bank_B_wdata[20] VDD VSS sg13cmos5l_buf_1
Xinput73 input73/X bank_B_wdata[30] VDD VSS sg13cmos5l_buf_1
Xinput95 _7714_/D quant_cfg[23] VDD VSS sg13cmos5l_buf_1
Xinput84 _4257_/B quant_cfg[11] VDD VSS sg13cmos5l_buf_1
X_6323_ _6335_/A _6576_/A _6621_/B VDD VSS sg13cmos5l_nor2_1
X_6254_ _6908_/B _6254_/A VDD VSS sg13cmos5l_buf_8
X_5205_ _5206_/C _5572_/A VDD VSS sg13cmos5l_inv_1
X_6185_ _6185_/X _6212_/A VDD VSS sg13cmos5l_buf_1
X_5136_ _5137_/B _5182_/A _5182_/B VDD VSS sg13cmos5l_xor2_1
X_5067_ _5123_/B _5135_/A _5067_/B VDD VSS sg13cmos5l_xnor2_1
X_4018_ _4122_/A _4018_/A VDD VSS sg13cmos5l_buf_1
XFILLER_53_742 VDD VSS sg13cmos5l_decap_8
XFILLER_41_926 VDD VSS sg13cmos5l_decap_8
XFILLER_53_764 VDD VSS sg13cmos5l_fill_1
X_5969_ _5971_/C _6015_/B _6015_/A VDD VSS sg13cmos5l_xor2_1
X_7708_ _7708_/Q clkload9/A _7708_/D fanout390/X VDD VSS sg13cmos5l_dfrbpq_1
XFILLER_32_23 VDD VSS sg13cmos5l_decap_4
X_7639_ _7640_/A _7657_/A _7639_/B VDD VSS sg13cmos5l_nand2_2
XFILLER_79_149 VDD VSS sg13cmos5l_decap_8
XFILLER_57_42 VDD VSS sg13cmos5l_fill_2
XFILLER_76_878 VDD VSS sg13cmos5l_fill_2
XFILLER_76_889 VDD VSS sg13cmos5l_fill_2
XFILLER_75_377 VDD VSS sg13cmos5l_decap_4
XFILLER_75_366 VDD VSS sg13cmos5l_decap_4
XFILLER_35_208 VDD VSS sg13cmos5l_fill_2
XFILLER_57_97 VDD VSS sg13cmos5l_fill_2
XFILLER_73_52 VDD VSS sg13cmos5l_decap_8
XFILLER_85_8 VDD VSS sg13cmos5l_decap_8
XFILLER_79_683 VDD VSS sg13cmos5l_fill_2
XFILLER_78_160 VDD VSS sg13cmos5l_fill_1
XFILLER_67_823 VDD VSS sg13cmos5l_decap_8
XFILLER_39_503 VDD VSS sg13cmos5l_fill_1
XFILLER_67_867 VDD VSS sg13cmos5l_fill_1
XFILLER_67_856 VDD VSS sg13cmos5l_decap_8
XFILLER_81_303 VDD VSS sg13cmos5l_decap_8
XFILLER_54_506 VDD VSS sg13cmos5l_decap_4
XFILLER_54_528 VDD VSS sg13cmos5l_fill_2
XFILLER_35_742 VDD VSS sg13cmos5l_decap_4
XFILLER_35_720 VDD VSS sg13cmos5l_fill_2
X_6941_ _6941_/Y _6941_/A _6941_/B VDD VSS sg13cmos5l_nand2_1
XFILLER_35_753 VDD VSS sg13cmos5l_fill_2
X_6872_ _6872_/Y _6872_/A VDD VSS sg13cmos5l_inv_1
XFILLER_62_550 VDD VSS sg13cmos5l_decap_8
X_5823_ _5824_/B _5821_/Y _5772_/A _5822_/Y VDD VSS sg13cmos5l_a21oi_1
XFILLER_35_786 VDD VSS sg13cmos5l_decap_8
XFILLER_35_797 VDD VSS sg13cmos5l_decap_4
X_5754_ _5817_/B _5754_/A _5754_/B VDD VSS sg13cmos5l_nand2_1
XFILLER_50_789 VDD VSS sg13cmos5l_fill_1
X_4705_ _4706_/B _4932_/A _4529_/X _4872_/A _4530_/X VDD VSS sg13cmos5l_a22oi_1
X_5685_ _5685_/X _5685_/A VDD VSS sg13cmos5l_buf_1
X_7424_ _7570_/B _7424_/A VDD VSS sg13cmos5l_buf_4
X_4636_ _4637_/B _4680_/A _4680_/B VDD VSS sg13cmos5l_xor2_1
X_7355_ _7361_/A _7355_/A _7355_/B _7518_/A VDD VSS sg13cmos5l_nand3_1
X_6306_ _6308_/A _6307_/A _6317_/C _7663_/Q VDD VSS sg13cmos5l_a21oi_1
X_4567_ _4616_/B _4618_/S _4567_/B VDD VSS sg13cmos5l_xnor2_1
X_4498_ _4560_/B _5044_/A _4498_/B VDD VSS sg13cmos5l_xnor2_1
X_7286_ _7290_/B _7166_/A _7276_/S _7285_/Y VDD VSS sg13cmos5l_a21oi_1
X_6237_ _6242_/A _6355_/A VDD VSS sg13cmos5l_inv_2
XFILLER_94_18 VDD VSS sg13cmos5l_decap_8
X_6168_ _6169_/B _6168_/A _6168_/B VDD VSS sg13cmos5l_xnor2_1
Xhold2088 _6183_/A _7721_/Q VDD VSS sg13cmos5l_dlygate4sd3_1
X_5119_ _5119_/X _5119_/A VDD VSS sg13cmos5l_buf_1
XFILLER_58_856 VDD VSS sg13cmos5l_decap_8
XFILLER_58_867 VDD VSS sg13cmos5l_fill_1
XFILLER_73_815 VDD VSS sg13cmos5l_decap_8
X_6099_ _6132_/B _6128_/A _6099_/B VDD VSS sg13cmos5l_xnor2_1
XFILLER_38_580 VDD VSS sg13cmos5l_fill_2
XFILLER_40_211 VDD VSS sg13cmos5l_decap_8
XFILLER_53_561 VDD VSS sg13cmos5l_fill_2
XFILLER_53_583 VDD VSS sg13cmos5l_decap_8
XFILLER_53_572 VDD VSS sg13cmos5l_fill_1
Xrebuffer740 rebuffer740/X rebuffer741/X VDD VSS sg13cmos5l_buf_1
Xrebuffer751 rebuffer751/X _6925_/A VDD VSS sg13cmos5l_buf_1
Xrebuffer773 _7547_/A _7332_/A VDD VSS sg13cmos5l_buf_1
Xrebuffer784 _7638_/B _7043_/A VDD VSS sg13cmos5l_buf_1
Xrebuffer762 rebuffer762/X _6900_/B VDD VSS sg13cmos5l_buf_1
XFILLER_4_27 VDD VSS sg13cmos5l_fill_2
XFILLER_48_300 VDD VSS sg13cmos5l_decap_4
XFILLER_75_130 VDD VSS sg13cmos5l_decap_4
XFILLER_48_333 VDD VSS sg13cmos5l_fill_2
XFILLER_48_366 VDD VSS sg13cmos5l_fill_1
XFILLER_75_174 VDD VSS sg13cmos5l_decap_8
XFILLER_48_388 VDD VSS sg13cmos5l_fill_2
XFILLER_72_870 VDD VSS sg13cmos5l_decap_4
X_5470_ _5474_/A _5530_/B _5470_/B VDD VSS sg13cmos5l_xnor2_1
X_4421_ _4495_/A _4421_/A _4421_/B VDD VSS sg13cmos5l_nand2_1
X_4352_ _4353_/B _4350_/Y _4347_/A _4351_/Y VDD VSS sg13cmos5l_o21ai_1
X_7140_ _7141_/B _7181_/A _7296_/B VDD VSS sg13cmos5l_nor2_1
X_4283_ _4337_/A _4283_/A _4336_/A VDD VSS sg13cmos5l_xnor2_1
X_7071_ _7071_/Y _6931_/A _7071_/B VDD VSS sg13cmos5l_nand2b_1
X_6022_ _6057_/B _6022_/A _6022_/B VDD VSS sg13cmos5l_xnor2_1
XFILLER_67_620 VDD VSS sg13cmos5l_fill_1
XFILLER_67_686 VDD VSS sg13cmos5l_fill_2
XFILLER_67_675 VDD VSS sg13cmos5l_decap_8
XFILLER_54_303 VDD VSS sg13cmos5l_fill_1
XFILLER_55_815 VDD VSS sg13cmos5l_decap_4
XFILLER_55_826 VDD VSS sg13cmos5l_decap_4
XFILLER_82_645 VDD VSS sg13cmos5l_decap_8
XFILLER_81_100 VDD VSS sg13cmos5l_decap_8
X_6924_ _7318_/B _7219_/A _7008_/B VDD VSS sg13cmos5l_nand2_1
XFILLER_81_177 VDD VSS sg13cmos5l_decap_8
X_6855_ _7012_/A _6947_/A _6957_/S _6854_/X VDD VSS sg13cmos5l_a21oi_1
X_3998_ _3998_/X _3998_/A VDD VSS sg13cmos5l_buf_1
X_6786_ _6974_/A _6786_/A _6786_/B VDD VSS sg13cmos5l_xor2_1
X_5806_ _5863_/B _5872_/A _5806_/B VDD VSS sg13cmos5l_xnor2_1
X_5737_ _5738_/A _5737_/A VDD VSS sg13cmos5l_inv_1
X_7407_ _7500_/A _7430_/A _7407_/B VDD VSS sg13cmos5l_xnor2_1
X_5668_ _5676_/A _5668_/A _5731_/B VDD VSS sg13cmos5l_nor2b_1
X_5599_ _5600_/A _5660_/A _5599_/B VDD VSS sg13cmos5l_xnor2_1
X_4619_ _4674_/S _4675_/B1 _4737_/A _3964_/C _5116_/A VDD VSS sg13cmos5l_a22oi_1
X_7338_ _7338_/Y _7437_/A2 _7394_/A2 _7343_/A VDD VSS sg13cmos5l_a21oi_1
X_7269_ _7269_/X _7268_/Y _7280_/A1 _7059_/Y VDD VSS sg13cmos5l_a21o_1
XFILLER_38_11 VDD VSS sg13cmos5l_decap_8
XFILLER_38_88 VDD VSS sg13cmos5l_decap_8
XFILLER_73_623 VDD VSS sg13cmos5l_fill_1
XFILLER_54_892 VDD VSS sg13cmos5l_fill_1
XFILLER_41_531 VDD VSS sg13cmos5l_fill_1
XFILLER_41_564 VDD VSS sg13cmos5l_fill_1
XFILLER_70_86 VDD VSS sg13cmos5l_decap_8
XFILLER_70_97 VDD VSS sg13cmos5l_fill_2
XFILLER_48_8 VDD VSS sg13cmos5l_fill_2
XFILLER_68_417 VDD VSS sg13cmos5l_decap_4
Xbank_A_sram.gen_ihp_256x32.u_sram_256x32_441 bank_A_sram.gen_ihp_256x32.u_sram_256x32_441/L_LO
+ VDD VSS sg13cmos5l_tielo
Xbank_A_sram.gen_ihp_256x32.u_sram_256x32_452 bank_A_sram.gen_ihp_256x32.u_sram_256x32_452/L_LO
+ VDD VSS sg13cmos5l_tielo
Xbank_A_sram.gen_ihp_256x32.u_sram_256x32_463 bank_A_sram.gen_ihp_256x32.u_sram_256x32_463/L_LO
+ VDD VSS sg13cmos5l_tielo
Xbank_A_sram.gen_ihp_256x32.u_sram_256x32_430 bank_A_sram.gen_ihp_256x32.u_sram_256x32_430/L_LO
+ VDD VSS sg13cmos5l_tielo
XFILLER_49_642 VDD VSS sg13cmos5l_fill_2
XFILLER_76_450 VDD VSS sg13cmos5l_decap_4
XFILLER_48_141 VDD VSS sg13cmos5l_fill_2
XFILLER_36_347 VDD VSS sg13cmos5l_decap_4
X_4970_ _5035_/A _4970_/A _4970_/B VDD VSS sg13cmos5l_nand2_1
XFILLER_44_391 VDD VSS sg13cmos5l_fill_2
XFILLER_51_339 VDD VSS sg13cmos5l_decap_4
X_6640_ _6642_/A _6641_/A _6641_/C _7699_/Q VDD VSS sg13cmos5l_a21oi_1
X_6571_ _6572_/A _7690_/Q _6571_/B VDD VSS sg13cmos5l_or2_1
X_5522_ _5523_/B _5712_/A _5644_/A2 _5698_/A _5644_/B2 VDD VSS sg13cmos5l_a22oi_1
XFILLER_67_0 VDD VSS sg13cmos5l_fill_2
X_5453_ _5453_/Y _5453_/A _5453_/B VDD VSS sg13cmos5l_nor2_1
X_5384_ _5434_/A _5442_/A _5384_/B VDD VSS sg13cmos5l_xnor2_1
X_4404_ _4404_/X _4404_/A _4404_/B VDD VSS sg13cmos5l_and2_1
X_7123_ _7151_/A _7123_/A _7123_/B _7641_/B VDD VSS sg13cmos5l_nand3_1
Xfanout205 _7603_/A _7467_/B VDD VSS sg13cmos5l_buf_1
X_4335_ _4404_/B _4400_/B _4400_/A VDD VSS sg13cmos5l_xor2_1
Xfanout216 _5756_/A2 _5199_/X VDD VSS sg13cmos5l_buf_1
Xfanout227 _7456_/A _7570_/B VDD VSS sg13cmos5l_buf_1
XFILLER_59_428 VDD VSS sg13cmos5l_decap_8
Xfanout238 _5568_/A _4996_/X VDD VSS sg13cmos5l_buf_1
Xfanout249 _4530_/A _3981_/X VDD VSS sg13cmos5l_buf_1
X_4266_ _4305_/B _4266_/A _4266_/B VDD VSS sg13cmos5l_xnor2_1
X_7054_ _7054_/X _7054_/A _7072_/B VDD VSS sg13cmos5l_and2_1
X_4197_ _4228_/A _4180_/B _4180_/A _4196_/Y VDD VSS sg13cmos5l_a21oi_1
XFILLER_39_141 VDD VSS sg13cmos5l_decap_8
XFILLER_39_152 VDD VSS sg13cmos5l_fill_2
X_6005_ _6007_/B _6005_/A _5964_/A VDD VSS sg13cmos5l_nor2b_1
XFILLER_43_807 VDD VSS sg13cmos5l_fill_1
XFILLER_82_464 VDD VSS sg13cmos5l_fill_1
XFILLER_54_177 VDD VSS sg13cmos5l_fill_2
XFILLER_35_391 VDD VSS sg13cmos5l_decap_8
X_6907_ _7127_/A _6903_/Y _6996_/A _6906_/Y VDD VSS sg13cmos5l_a21oi_1
XFILLER_51_851 VDD VSS sg13cmos5l_fill_2
XFILLER_51_840 VDD VSS sg13cmos5l_fill_1
X_6838_ _6939_/B _6838_/A _6838_/B VDD VSS sg13cmos5l_xnor2_1
X_6769_ _6769_/Y _6769_/A1 _6860_/A _6573_/B VDD VSS sg13cmos5l_a21oi_1
Xclkbuf_4_0_0_clk_i_regs _7724_/CLK clkbuf_0_clk_i_regs/X VDD VSS sg13cmos5l_buf_8
XFILLER_77_247 VDD VSS sg13cmos5l_decap_8
XFILLER_77_269 VDD VSS sg13cmos5l_decap_4
XFILLER_1_28 VDD VSS sg13cmos5l_fill_1
XFILLER_46_623 VDD VSS sg13cmos5l_decap_8
XFILLER_58_472 VDD VSS sg13cmos5l_fill_2
XFILLER_73_431 VDD VSS sg13cmos5l_fill_1
XFILLER_45_155 VDD VSS sg13cmos5l_decap_4
XFILLER_61_637 VDD VSS sg13cmos5l_fill_1
XFILLER_81_52 VDD VSS sg13cmos5l_decap_8
XFILLER_41_372 VDD VSS sg13cmos5l_decap_4
X_4120_ _4120_/Y _4120_/A _4120_/B VDD VSS sg13cmos5l_nor2_1
XFILLER_69_748 VDD VSS sg13cmos5l_decap_8
X_4051_ _4095_/A _4032_/B _4032_/A _4050_/Y VDD VSS sg13cmos5l_a21oi_2
XFILLER_49_450 VDD VSS sg13cmos5l_decap_8
XFILLER_77_770 VDD VSS sg13cmos5l_decap_8
Xinput5 input5/X bank_A_addr[4] VDD VSS sg13cmos5l_buf_1
XFILLER_49_472 VDD VSS sg13cmos5l_fill_2
XFILLER_76_280 VDD VSS sg13cmos5l_fill_2
XFILLER_36_144 VDD VSS sg13cmos5l_decap_8
XFILLER_64_442 VDD VSS sg13cmos5l_fill_2
X_4953_ _4954_/B _4953_/A _4953_/B VDD VSS sg13cmos5l_xor2_1
XFILLER_51_125 VDD VSS sg13cmos5l_fill_2
X_7672_ _7672_/Q _7675_/CLK _7672_/D fanout387/X VDD VSS sg13cmos5l_dfrbpq_1
X_4884_ _4885_/B _5000_/A _4640_/X _4932_/A _4641_/X VDD VSS sg13cmos5l_a22oi_1
X_6623_ _6631_/C _6623_/A VDD VSS sg13cmos5l_inv_1
X_6554_ _6869_/B _6554_/A _6554_/B VDD VSS sg13cmos5l_nand2_1
X_5505_ _5505_/X _5505_/A VDD VSS sg13cmos5l_buf_1
X_6485_ _6485_/Y _6485_/A _6485_/B VDD VSS sg13cmos5l_nor2_1
XFILLER_10_26 VDD VSS sg13cmos5l_fill_2
X_5436_ _5437_/B _5436_/A _5490_/A VDD VSS sg13cmos5l_xnor2_1
X_5367_ _5411_/A _5317_/B _5317_/A _5366_/Y VDD VSS sg13cmos5l_a21oi_1
X_5298_ _5299_/A _5298_/A _5233_/A VDD VSS sg13cmos5l_nor2b_1
X_7106_ _7106_/Y _7106_/A VDD VSS sg13cmos5l_inv_1
X_4318_ _4400_/B _4318_/A _4318_/B VDD VSS sg13cmos5l_xor2_1
X_4249_ _4293_/B _4249_/A _4350_/A VDD VSS sg13cmos5l_nor2_1
XFILLER_19_24 VDD VSS sg13cmos5l_decap_4
XFILLER_47_409 VDD VSS sg13cmos5l_decap_8
X_7037_ _7038_/A _7164_/B _6796_/X _7036_/Y VDD VSS sg13cmos5l_a21oi_1
XFILLER_67_280 VDD VSS sg13cmos5l_fill_2
XFILLER_70_401 VDD VSS sg13cmos5l_fill_2
XFILLER_43_604 VDD VSS sg13cmos5l_fill_1
XFILLER_55_486 VDD VSS sg13cmos5l_decap_8
XFILLER_35_45 VDD VSS sg13cmos5l_decap_8
XFILLER_35_78 VDD VSS sg13cmos5l_decap_4
XFILLER_51_44 VDD VSS sg13cmos5l_fill_1
XFILLER_66_707 VDD VSS sg13cmos5l_fill_2
XFILLER_59_770 VDD VSS sg13cmos5l_fill_2
XFILLER_76_96 VDD VSS sg13cmos5l_decap_8
XFILLER_58_280 VDD VSS sg13cmos5l_decap_8
XFILLER_73_250 VDD VSS sg13cmos5l_fill_1
XFILLER_61_445 VDD VSS sg13cmos5l_decap_8
XFILLER_61_467 VDD VSS sg13cmos5l_fill_1
X_6270_ _6273_/A _6270_/A _6293_/A VDD VSS sg13cmos5l_nand2_2
X_5221_ _5292_/B _5221_/A _5237_/B VDD VSS sg13cmos5l_xnor2_1
X_5152_ _5153_/B _5152_/A _5152_/B VDD VSS sg13cmos5l_xor2_1
X_4103_ _4103_/Y _6181_/A _6181_/B VDD VSS sg13cmos5l_nand2_2
X_5083_ _5084_/B _5269_/A _5644_/A2 _5257_/A _5644_/B2 VDD VSS sg13cmos5l_a22oi_1
XFILLER_57_729 VDD VSS sg13cmos5l_decap_4
X_4034_ _4034_/Y _4034_/A _4010_/A VDD VSS sg13cmos5l_nor2b_1
XFILLER_37_486 VDD VSS sg13cmos5l_fill_2
XFILLER_65_795 VDD VSS sg13cmos5l_decap_8
X_7724_ _7724_/Q _7724_/CLK _7724_/D fanout384/X VDD VSS sg13cmos5l_dfrbpq_1
X_5985_ _6024_/S _6026_/B1 _6114_/A _5985_/B1 _6026_/B2 VDD VSS sg13cmos5l_a22oi_1
X_4936_ _4990_/B _5446_/A _4936_/B VDD VSS sg13cmos5l_xnor2_1
XANTENNA_10 _4169_/A VDD VSS sg13cmos5l_antennanp
XANTENNA_21 quant_cfg[0] VDD VSS sg13cmos5l_antennanp
X_4867_ _4867_/Y _4867_/A _4833_/B VDD VSS sg13cmos5l_nor2b_1
X_7655_ _7656_/A _7655_/A1 _7650_/B _7177_/B VDD VSS sg13cmos5l_a21oi_1
X_6606_ _6607_/B _6614_/A _6605_/X _6649_/A VDD VSS sg13cmos5l_o21ai_1
X_7586_ _7587_/B _7583_/B _7583_/A _7585_/Y VDD VSS sg13cmos5l_a21oi_1
X_6537_ _6870_/B _6537_/A _7687_/Q _6589_/A VDD VSS sg13cmos5l_nand3_1
X_4798_ _4806_/A _4741_/B _4854_/A _4798_/S VDD VSS sg13cmos5l_mux2_1
XFILLER_115_8 VDD VSS sg13cmos5l_decap_8
X_6468_ _6468_/X _6468_/A _6468_/B VDD VSS sg13cmos5l_and2_1
X_5419_ _5420_/B _5419_/A _5419_/B VDD VSS sg13cmos5l_nor2_1
Xoutput161 bank_B_rdata[21] output161/A VDD VSS sg13cmos5l_buf_1
Xoutput150 bank_B_rdata[11] output150/A VDD VSS sg13cmos5l_buf_1
X_6399_ _6401_/A _6408_/A _6679_/B VDD VSS sg13cmos5l_nand2_1
Xoutput172 bank_B_rdata[31] wire372/X VDD VSS sg13cmos5l_buf_1
XFILLER_75_504 VDD VSS sg13cmos5l_decap_8
XFILLER_46_33 VDD VSS sg13cmos5l_fill_2
XFILLER_44_913 VDD VSS sg13cmos5l_decap_8
XFILLER_55_283 VDD VSS sg13cmos5l_fill_2
XFILLER_71_798 VDD VSS sg13cmos5l_decap_8
XFILLER_70_264 VDD VSS sg13cmos5l_decap_8
XFILLER_62_65 VDD VSS sg13cmos5l_fill_2
XFILLER_30_8 VDD VSS sg13cmos5l_fill_1
XFILLER_78_353 VDD VSS sg13cmos5l_fill_1
XFILLER_39_707 VDD VSS sg13cmos5l_fill_1
XFILLER_66_515 VDD VSS sg13cmos5l_fill_1
XFILLER_66_504 VDD VSS sg13cmos5l_decap_8
XFILLER_38_228 VDD VSS sg13cmos5l_decap_8
XFILLER_47_751 VDD VSS sg13cmos5l_fill_1
XFILLER_62_710 VDD VSS sg13cmos5l_fill_1
XFILLER_46_272 VDD VSS sg13cmos5l_decap_8
XFILLER_61_253 VDD VSS sg13cmos5l_decap_4
XFILLER_62_776 VDD VSS sg13cmos5l_fill_1
X_5770_ _5822_/B _5719_/B _5719_/A _5769_/Y VDD VSS sg13cmos5l_a21oi_1
X_4721_ _4721_/X _4721_/A _4721_/B VDD VSS sg13cmos5l_and2_1
X_4652_ _4653_/B _4695_/A _4695_/B VDD VSS sg13cmos5l_xor2_1
X_7440_ _7441_/A _7585_/B _7436_/B _7464_/B VDD VSS sg13cmos5l_a21o_1
Xinput30 input30/X bank_A_wdata[29] VDD VSS sg13cmos5l_buf_1
X_7371_ _7373_/A _6418_/Y _7226_/Y _7370_/Y VDD VSS sg13cmos5l_o21ai_1
X_4583_ _4584_/B _4688_/A _4640_/A _4631_/A _4641_/A VDD VSS sg13cmos5l_a22oi_1
Xinput52 input52/X bank_B_wdata[11] VDD VSS sg13cmos5l_buf_1
Xinput63 input63/X bank_B_wdata[21] VDD VSS sg13cmos5l_buf_1
Xinput41 _3927_/A bank_A_we VDD VSS sg13cmos5l_buf_1
Xinput96 _7715_/D quant_cfg[24] VDD VSS sg13cmos5l_buf_1
Xinput85 _4300_/B quant_cfg[12] VDD VSS sg13cmos5l_buf_1
Xinput74 input74/X bank_B_wdata[31] VDD VSS sg13cmos5l_buf_1
X_6322_ _6621_/B _6611_/B _6483_/B VDD VSS sg13cmos5l_nand2_1
X_6253_ _6785_/A _6353_/A _6259_/A VDD VSS sg13cmos5l_nor2_2
X_5204_ _5207_/A _5517_/A _5572_/A _4944_/X VDD VSS sg13cmos5l_a21oi_1
X_6184_ _6212_/A psum_lut_en VDD VSS sg13cmos5l_buf_1
X_5135_ _5182_/B _5135_/A _5135_/B VDD VSS sg13cmos5l_xnor2_1
X_5066_ _5067_/B _4932_/X _4876_/X _4872_/X _4877_/X VDD VSS sg13cmos5l_a22oi_1
X_4017_ _4018_/A _4043_/A _5810_/A _4016_/Y VDD VSS sg13cmos5l_o21ai_1
XFILLER_37_294 VDD VSS sg13cmos5l_decap_8
XFILLER_16_25 VDD VSS sg13cmos5l_decap_4
XFILLER_41_905 VDD VSS sg13cmos5l_decap_8
XFILLER_52_231 VDD VSS sg13cmos5l_fill_1
X_5968_ _6015_/A _6042_/A _5927_/B _5967_/Y VDD VSS sg13cmos5l_o21ai_1
X_7707_ _7707_/Q clkload9/A _7707_/D fanout390/X VDD VSS sg13cmos5l_dfrbpq_2
X_4919_ _4927_/A _4862_/B _4854_/A _4919_/S VDD VSS sg13cmos5l_mux2_1
X_5899_ _5900_/A _5897_/B _6111_/A _5897_/Y _5898_/Y VDD VSS sg13cmos5l_a22oi_1
X_7638_ _7639_/B _7638_/A _7638_/B VDD VSS sg13cmos5l_xor2_1
X_7569_ _7573_/A _7620_/A _7620_/B _7569_/C _7569_/D VDD VSS sg13cmos5l_nor4_2
XFILLER_106_4 VDD VSS sg13cmos5l_decap_8
XFILLER_79_117 VDD VSS sg13cmos5l_decap_8
XFILLER_76_835 VDD VSS sg13cmos5l_fill_2
XFILLER_57_65 VDD VSS sg13cmos5l_decap_4
XFILLER_73_31 VDD VSS sg13cmos5l_fill_1
XFILLER_73_97 VDD VSS sg13cmos5l_fill_1
XFILLER_43_253 VDD VSS sg13cmos5l_decap_4
XFILLER_66_323 VDD VSS sg13cmos5l_fill_1
X_6940_ _6940_/Y _6879_/Y _6910_/S _6939_/Y VDD VSS sg13cmos5l_a21oi_1
XFILLER_47_570 VDD VSS sg13cmos5l_fill_1
XFILLER_47_581 VDD VSS sg13cmos5l_fill_2
XFILLER_81_359 VDD VSS sg13cmos5l_decap_8
X_6871_ _6872_/A _6871_/A _6871_/B VDD VSS sg13cmos5l_xor2_1
X_5822_ _5822_/Y _5822_/A _5822_/B VDD VSS sg13cmos5l_nor2_1
XFILLER_97_0 VDD VSS sg13cmos5l_decap_8
X_5753_ _5754_/A _5758_/A _5753_/B VDD VSS sg13cmos5l_nand2b_1
X_4704_ _4759_/A _4585_/X _5000_/A _4703_/Y VDD VSS sg13cmos5l_a21o_1
X_5684_ _5744_/S _5745_/B1 _5858_/A _5684_/B1 _6026_/B2 VDD VSS sg13cmos5l_a22oi_1
X_4635_ _4680_/B _4875_/A _4635_/B VDD VSS sg13cmos5l_xnor2_1
X_7423_ _7432_/A _7575_/A _7574_/A _7575_/B VDD VSS sg13cmos5l_nand3_1
X_7354_ _7518_/A _7354_/A VDD VSS sg13cmos5l_inv_1
X_4566_ _4567_/B _4621_/A _4566_/B VDD VSS sg13cmos5l_xnor2_1
X_6305_ _6307_/A _6314_/A _6314_/B VDD VSS sg13cmos5l_xnor2_1
X_7285_ _7285_/Y _7276_/S _7171_/Y _7397_/A VDD VSS sg13cmos5l_o21ai_1
X_4497_ _4498_/B _3965_/B _4737_/A _4203_/B _4561_/A VDD VSS sg13cmos5l_a22oi_1
X_6236_ _6355_/A _7710_/Q VDD VSS sg13cmos5l_buf_8
Xclkbuf_4_5_0_clk_i_regs clkload2/A clkbuf_0_clk_i_regs/X VDD VSS sg13cmos5l_buf_8
X_6167_ _6168_/B _6175_/C _6175_/A VDD VSS sg13cmos5l_xnor2_1
XFILLER_58_824 VDD VSS sg13cmos5l_decap_8
XFILLER_69_172 VDD VSS sg13cmos5l_decap_8
X_5118_ _5118_/X _5118_/A VDD VSS sg13cmos5l_buf_1
XFILLER_73_805 VDD VSS sg13cmos5l_fill_2
Xhold2089 _6192_/A _7723_/Q VDD VSS sg13cmos5l_dlygate4sd3_1
X_6098_ _6099_/B _6129_/B _6129_/A VDD VSS sg13cmos5l_xnor2_1
XFILLER_38_592 VDD VSS sg13cmos5l_decap_8
X_5049_ _5057_/A _4989_/B _5048_/A _5049_/S VDD VSS sg13cmos5l_mux2_1
XFILLER_80_381 VDD VSS sg13cmos5l_decap_8
XFILLER_40_267 VDD VSS sg13cmos5l_fill_1
Xrebuffer730 rebuffer730/X rebuffer731/X VDD VSS sg13cmos5l_buf_1
Xrebuffer741 rebuffer741/X rebuffer742/X VDD VSS sg13cmos5l_buf_1
Xrebuffer763 rebuffer763/X _7258_/A VDD VSS sg13cmos5l_buf_1
Xrebuffer774 _6753_/B _6627_/A VDD VSS sg13cmos5l_buf_1
Xrebuffer752 _6851_/B _6445_/A VDD VSS sg13cmos5l_buf_1
XFILLER_68_53 VDD VSS sg13cmos5l_decap_8
XFILLER_75_153 VDD VSS sg13cmos5l_fill_2
XFILLER_63_315 VDD VSS sg13cmos5l_decap_4
XFILLER_63_326 VDD VSS sg13cmos5l_decap_8
XFILLER_72_882 VDD VSS sg13cmos5l_fill_1
XFILLER_40_790 VDD VSS sg13cmos5l_fill_1
X_4420_ _4421_/B _4621_/A _4494_/A VDD VSS sg13cmos5l_nand2_1
X_4351_ _4351_/Y _4351_/A _4351_/B VDD VSS sg13cmos5l_nand2_1
X_4282_ _4336_/A _4282_/A _4282_/B VDD VSS sg13cmos5l_xor2_1
X_7070_ _7070_/Y _7071_/B _6928_/Y _7069_/Y VDD VSS sg13cmos5l_o21ai_1
XFILLER_58_109 VDD VSS sg13cmos5l_fill_1
X_6021_ _6022_/B _6136_/B _5568_/X _6114_/B _5569_/X VDD VSS sg13cmos5l_a22oi_1
XFILLER_104_18 VDD VSS sg13cmos5l_decap_8
XFILLER_66_120 VDD VSS sg13cmos5l_decap_8
XFILLER_67_654 VDD VSS sg13cmos5l_fill_1
XFILLER_66_142 VDD VSS sg13cmos5l_decap_8
XFILLER_82_613 VDD VSS sg13cmos5l_fill_1
XFILLER_66_175 VDD VSS sg13cmos5l_decap_8
XFILLER_81_156 VDD VSS sg13cmos5l_decap_8
XFILLER_70_819 VDD VSS sg13cmos5l_decap_8
X_6923_ _7219_/A _6937_/A _7132_/A _6922_/Y VDD VSS sg13cmos5l_o21ai_1
XFILLER_35_562 VDD VSS sg13cmos5l_decap_4
X_6854_ _6854_/X _6955_/A _6960_/B VDD VSS sg13cmos5l_and2_1
XFILLER_62_392 VDD VSS sg13cmos5l_decap_8
X_3997_ _3998_/A _3997_/A VDD VSS sg13cmos5l_buf_1
X_5805_ _5806_/B _5698_/X _5943_/A2 _5633_/X _5943_/B2 VDD VSS sg13cmos5l_a22oi_1
XFILLER_13_15 VDD VSS sg13cmos5l_decap_8
X_6785_ _6785_/X _6785_/A VDD VSS sg13cmos5l_buf_2
X_5736_ _5786_/A _5736_/A _5736_/B _5736_/C VDD VSS sg13cmos5l_nand3_1
X_5667_ _5731_/B _5667_/A _5667_/B _5667_/C VDD VSS sg13cmos5l_nand3_1
X_4618_ _4626_/A _4567_/B _4487_/X _4618_/S VDD VSS sg13cmos5l_mux2_1
X_7406_ _7407_/B _7404_/X _7295_/Y _7405_/Y VDD VSS sg13cmos5l_o21ai_1
X_5598_ _5599_/B _5598_/A _5598_/B VDD VSS sg13cmos5l_xor2_1
X_7337_ _7342_/A _7337_/A _7524_/B _7525_/B VDD VSS sg13cmos5l_nand3_1
X_4549_ _4668_/B _4549_/A _4544_/A VDD VSS sg13cmos5l_nor2b_1
X_7268_ _7268_/Y _7268_/A1 _7294_/B _7182_/A VDD VSS sg13cmos5l_a21oi_1
XFILLER_77_407 VDD VSS sg13cmos5l_decap_4
X_6219_ _6219_/Y _6219_/A _6219_/B VDD VSS sg13cmos5l_nand2_1
X_7199_ _7201_/A _6630_/A _7356_/A _7198_/Y VDD VSS sg13cmos5l_o21ai_1
XFILLER_38_67 VDD VSS sg13cmos5l_decap_8
XFILLER_57_153 VDD VSS sg13cmos5l_decap_4
XFILLER_57_142 VDD VSS sg13cmos5l_decap_8
XFILLER_72_112 VDD VSS sg13cmos5l_decap_4
XFILLER_72_167 VDD VSS sg13cmos5l_decap_8
XFILLER_53_392 VDD VSS sg13cmos5l_decap_8
XFILLER_54_99 VDD VSS sg13cmos5l_decap_8
XFILLER_70_65 VDD VSS sg13cmos5l_decap_8
XFILLER_79_74 VDD VSS sg13cmos5l_fill_1
XFILLER_69_919 VDD VSS sg13cmos5l_fill_1
Xbank_A_sram.gen_ihp_256x32.u_sram_256x32_420 bank_A_sram.gen_ihp_256x32.u_sram_256x32_420/L_LO
+ VDD VSS sg13cmos5l_tielo
Xbank_A_sram.gen_ihp_256x32.u_sram_256x32_442 bank_A_sram.gen_ihp_256x32.u_sram_256x32_442/L_LO
+ VDD VSS sg13cmos5l_tielo
Xbank_A_sram.gen_ihp_256x32.u_sram_256x32_453 bank_A_sram.gen_ihp_256x32.u_sram_256x32_453/L_LO
+ VDD VSS sg13cmos5l_tielo
Xbank_A_sram.gen_ihp_256x32.u_sram_256x32_431 bank_A_sram.gen_ihp_256x32.u_sram_256x32_431/L_LO
+ VDD VSS sg13cmos5l_tielo
Xbank_A_sram.gen_ihp_256x32.u_sram_256x32_464 bank_A_sram.gen_ihp_256x32.u_sram_256x32_464/L_LO
+ VDD VSS sg13cmos5l_tielo
XFILLER_49_676 VDD VSS sg13cmos5l_decap_4
XFILLER_36_326 VDD VSS sg13cmos5l_decap_8
XFILLER_49_698 VDD VSS sg13cmos5l_fill_2
XFILLER_63_145 VDD VSS sg13cmos5l_fill_2
XFILLER_64_679 VDD VSS sg13cmos5l_decap_8
XFILLER_44_370 VDD VSS sg13cmos5l_decap_8
Xbank_B_sram.gen_ihp_256x32.u_sram_256x32_490 bank_B_sram.gen_ihp_256x32.u_sram_256x32_490/L_LO
+ VDD VSS sg13cmos5l_tielo
X_6570_ _6573_/B _7691_/Q _6570_/B VDD VSS sg13cmos5l_xnor2_1
X_5521_ _5579_/B _5518_/Y _5460_/A _5520_/Y VDD VSS sg13cmos5l_a21oi_1
X_5452_ _5468_/A _5452_/A _5452_/B VDD VSS sg13cmos5l_xor2_1
X_4403_ _4414_/B _4403_/A _4403_/B VDD VSS sg13cmos5l_xor2_1
X_5383_ _5384_/B _5909_/B1 _5258_/X _5269_/X _5259_/X VDD VSS sg13cmos5l_a22oi_1
X_7122_ _7641_/B _7716_/Q _7122_/B VDD VSS sg13cmos5l_nand2b_1
X_4334_ _4400_/A _4334_/A _4399_/A VDD VSS sg13cmos5l_xnor2_1
X_7053_ _7191_/A _6917_/Y _7071_/B _7052_/X VDD VSS sg13cmos5l_a21o_1
Xfanout217 _5686_/A _5119_/X VDD VSS sg13cmos5l_buf_1
Xfanout206 _7472_/A1 _7404_/X VDD VSS sg13cmos5l_buf_1
Xfanout228 _7404_/A _7349_/X VDD VSS sg13cmos5l_buf_1
X_4265_ _4266_/B _4675_/B1 _4313_/A _3963_/X _4314_/A VDD VSS sg13cmos5l_a22oi_1
Xfanout239 _5448_/A _4877_/X VDD VSS sg13cmos5l_buf_1
X_6004_ _6007_/C _6004_/A _6004_/B VDD VSS sg13cmos5l_nand2_1
X_4196_ _4196_/Y _4196_/A _4179_/B VDD VSS sg13cmos5l_nor2b_1
XFILLER_67_451 VDD VSS sg13cmos5l_fill_2
XFILLER_39_120 VDD VSS sg13cmos5l_decap_8
XFILLER_82_410 VDD VSS sg13cmos5l_fill_1
XFILLER_82_443 VDD VSS sg13cmos5l_decap_8
XFILLER_55_657 VDD VSS sg13cmos5l_fill_1
XFILLER_43_819 VDD VSS sg13cmos5l_fill_1
XFILLER_36_893 VDD VSS sg13cmos5l_decap_8
X_6906_ _6906_/Y _6913_/B _6906_/B VDD VSS sg13cmos5l_nor2_1
X_6837_ _6838_/B _6837_/A _6837_/B VDD VSS sg13cmos5l_nand2_1
XFILLER_51_863 VDD VSS sg13cmos5l_decap_8
XFILLER_50_384 VDD VSS sg13cmos5l_fill_1
X_6768_ _6976_/B _6768_/A VDD VSS sg13cmos5l_buf_2
X_5719_ _5742_/B _5719_/A _5719_/B VDD VSS sg13cmos5l_xnor2_1
X_6699_ _6700_/B _6699_/A VDD VSS sg13cmos5l_inv_1
XFILLER_77_204 VDD VSS sg13cmos5l_fill_2
XFILLER_49_33 VDD VSS sg13cmos5l_decap_8
XFILLER_77_226 VDD VSS sg13cmos5l_decap_8
XFILLER_49_77 VDD VSS sg13cmos5l_fill_1
XFILLER_74_933 VDD VSS sg13cmos5l_fill_1
XFILLER_46_668 VDD VSS sg13cmos5l_decap_4
XFILLER_65_43 VDD VSS sg13cmos5l_decap_8
XFILLER_54_690 VDD VSS sg13cmos5l_decap_8
XFILLER_60_126 VDD VSS sg13cmos5l_fill_2
XFILLER_81_31 VDD VSS sg13cmos5l_decap_4
XFILLER_81_86 VDD VSS sg13cmos5l_decap_8
XFILLER_68_226 VDD VSS sg13cmos5l_decap_8
X_4050_ _4050_/Y _4050_/A _4050_/B VDD VSS sg13cmos5l_nor2_1
XFILLER_49_462 VDD VSS sg13cmos5l_fill_2
Xinput6 input6/X bank_A_addr[5] VDD VSS sg13cmos5l_buf_1
XFILLER_65_933 VDD VSS sg13cmos5l_fill_1
XFILLER_37_668 VDD VSS sg13cmos5l_fill_1
XFILLER_36_123 VDD VSS sg13cmos5l_decap_8
X_4952_ _4953_/B _5007_/A _5007_/B VDD VSS sg13cmos5l_xor2_1
XFILLER_51_115 VDD VSS sg13cmos5l_fill_2
X_4883_ _4928_/A _4832_/B _4832_/A _4882_/Y VDD VSS sg13cmos5l_a21oi_1
X_7671_ _7671_/Q clkload6/A _7671_/D fanout387/X VDD VSS sg13cmos5l_dfrbpq_1
X_6622_ _6622_/Y _6623_/A _6631_/B VDD VSS sg13cmos5l_nor2b_1
X_6553_ _6555_/B _6553_/A _6861_/B VDD VSS sg13cmos5l_nor2b_1
X_6484_ _6491_/A _6484_/A _6485_/A VDD VSS sg13cmos5l_nor2b_2
X_5504_ _5511_/A _5630_/A _5504_/B VDD VSS sg13cmos5l_xnor2_1
X_5435_ _5490_/A _5388_/B _5388_/A _5434_/X VDD VSS sg13cmos5l_a21oi_1
X_5366_ _5366_/Y _5366_/A _5366_/B VDD VSS sg13cmos5l_nor2_1
XFILLER_59_204 VDD VSS sg13cmos5l_fill_2
X_5297_ _5360_/B _5297_/A _5359_/A VDD VSS sg13cmos5l_xnor2_1
X_7105_ _7106_/A _7105_/A _7105_/B VDD VSS sg13cmos5l_nand2_1
XFILLER_59_237 VDD VSS sg13cmos5l_decap_8
X_4317_ _4318_/B _4369_/A _4369_/B VDD VSS sg13cmos5l_xor2_1
XFILLER_75_708 VDD VSS sg13cmos5l_decap_4
X_4248_ _4249_/A _4248_/A _4237_/A VDD VSS sg13cmos5l_nor2b_1
X_7036_ _7036_/Y _7036_/A _7170_/A VDD VSS sg13cmos5l_nor2_1
XFILLER_74_218 VDD VSS sg13cmos5l_decap_8
XFILLER_68_793 VDD VSS sg13cmos5l_decap_8
XFILLER_56_933 VDD VSS sg13cmos5l_fill_1
X_4179_ _4180_/B _4196_/A _4179_/B VDD VSS sg13cmos5l_xnor2_1
XFILLER_55_443 VDD VSS sg13cmos5l_decap_4
XFILLER_82_251 VDD VSS sg13cmos5l_decap_4
XFILLER_42_115 VDD VSS sg13cmos5l_decap_4
XFILLER_43_627 VDD VSS sg13cmos5l_fill_2
XFILLER_43_649 VDD VSS sg13cmos5l_decap_8
XFILLER_55_498 VDD VSS sg13cmos5l_decap_8
XFILLER_51_693 VDD VSS sg13cmos5l_decap_4
XFILLER_51_67 VDD VSS sg13cmos5l_decap_8
XFILLER_78_502 VDD VSS sg13cmos5l_decap_8
XFILLER_47_900 VDD VSS sg13cmos5l_decap_8
XFILLER_47_911 VDD VSS sg13cmos5l_fill_2
XFILLER_46_410 VDD VSS sg13cmos5l_decap_8
XFILLER_46_421 VDD VSS sg13cmos5l_fill_1
XFILLER_46_432 VDD VSS sg13cmos5l_decap_8
XFILLER_73_240 VDD VSS sg13cmos5l_fill_2
XFILLER_61_402 VDD VSS sg13cmos5l_fill_2
XFILLER_62_914 VDD VSS sg13cmos5l_fill_1
XFILLER_41_170 VDD VSS sg13cmos5l_decap_4
X_5220_ _5237_/B _5238_/B _5238_/A VDD VSS sg13cmos5l_xor2_1
X_5151_ _5152_/B _5197_/A _5197_/B VDD VSS sg13cmos5l_xor2_1
XFILLER_69_535 VDD VSS sg13cmos5l_fill_2
XFILLER_69_513 VDD VSS sg13cmos5l_decap_8
X_4102_ _6181_/B _4040_/B _4102_/B VDD VSS sg13cmos5l_nand2b_1
X_5082_ _5082_/X _5082_/A VDD VSS sg13cmos5l_buf_1
XFILLER_57_719 VDD VSS sg13cmos5l_decap_4
X_4033_ _4033_/Y _4033_/A VDD VSS sg13cmos5l_inv_1
XFILLER_49_281 VDD VSS sg13cmos5l_fill_1
XFILLER_65_730 VDD VSS sg13cmos5l_fill_2
XFILLER_112_18 VDD VSS sg13cmos5l_decap_8
XFILLER_80_700 VDD VSS sg13cmos5l_decap_8
XFILLER_53_925 VDD VSS sg13cmos5l_decap_8
XFILLER_65_763 VDD VSS sg13cmos5l_decap_4
XFILLER_65_774 VDD VSS sg13cmos5l_decap_8
XFILLER_52_413 VDD VSS sg13cmos5l_decap_4
X_7723_ _7723_/Q _7728_/CLK _7723_/D fanout391/X VDD VSS sg13cmos5l_dfrbpq_1
XFILLER_52_446 VDD VSS sg13cmos5l_decap_8
X_5984_ _5993_/A _5952_/B _5788_/A _5984_/S VDD VSS sg13cmos5l_mux2_1
XFILLER_40_619 VDD VSS sg13cmos5l_fill_2
X_4935_ _4936_/B _4811_/X _5447_/A _4750_/X _5448_/A VDD VSS sg13cmos5l_a22oi_1
XANTENNA_11 _4169_/A VDD VSS sg13cmos5l_antennanp
XANTENNA_22 quant_cfg[0] VDD VSS sg13cmos5l_antennanp
X_7654_ _7726_/D _7654_/A _7658_/B VDD VSS sg13cmos5l_nand2_2
X_4866_ _4958_/A _4866_/A _4866_/B VDD VSS sg13cmos5l_xor2_1
XFILLER_60_490 VDD VSS sg13cmos5l_fill_1
X_6605_ _6605_/X _6605_/A _6605_/B VDD VSS sg13cmos5l_and2_1
X_4797_ _4905_/A _4745_/B _4745_/A _4796_/Y VDD VSS sg13cmos5l_a21oi_1
X_7585_ _7585_/Y _7585_/A _7585_/B VDD VSS sg13cmos5l_nor2_1
X_6536_ _6538_/A _6537_/A _6589_/A _7687_/Q VDD VSS sg13cmos5l_a21oi_1
XFILLER_21_15 VDD VSS sg13cmos5l_decap_8
X_6467_ _6476_/A _6468_/B _6468_/A VDD VSS sg13cmos5l_nor2_2
Xoutput140 bank_A_rdata[31] _5516_/A VDD VSS sg13cmos5l_buf_1
X_5418_ _5419_/B _5418_/A _5418_/B VDD VSS sg13cmos5l_nor2_1
Xoutput151 bank_B_rdata[12] output151/A VDD VSS sg13cmos5l_buf_1
X_6398_ _6679_/B _6541_/B _6697_/A VDD VSS sg13cmos5l_and2_1
Xoutput162 bank_B_rdata[22] output162/A VDD VSS sg13cmos5l_buf_1
Xoutput173 bank_B_rdata[3] _6219_/B VDD VSS sg13cmos5l_buf_1
X_5349_ _5350_/B _5349_/A _5349_/B VDD VSS sg13cmos5l_xor2_1
X_7019_ _7020_/A _6995_/X _6794_/A _7018_/Y VDD VSS sg13cmos5l_o21ai_1
XFILLER_56_774 VDD VSS sg13cmos5l_decap_8
XFILLER_43_402 VDD VSS sg13cmos5l_decap_8
XFILLER_43_413 VDD VSS sg13cmos5l_fill_1
XFILLER_56_796 VDD VSS sg13cmos5l_fill_1
XFILLER_71_777 VDD VSS sg13cmos5l_decap_8
XFILLER_70_276 VDD VSS sg13cmos5l_decap_8
XFILLER_70_298 VDD VSS sg13cmos5l_decap_8
XFILLER_79_822 VDD VSS sg13cmos5l_fill_2
XFILLER_78_332 VDD VSS sg13cmos5l_decap_8
XFILLER_78_365 VDD VSS sg13cmos5l_decap_4
XFILLER_38_207 VDD VSS sg13cmos5l_decap_8
XFILLER_23_8 VDD VSS sg13cmos5l_decap_8
XFILLER_81_519 VDD VSS sg13cmos5l_decap_8
XFILLER_35_903 VDD VSS sg13cmos5l_decap_8
XFILLER_35_914 VDD VSS sg13cmos5l_decap_8
XFILLER_46_251 VDD VSS sg13cmos5l_decap_8
XFILLER_74_593 VDD VSS sg13cmos5l_decap_8
XFILLER_46_295 VDD VSS sg13cmos5l_decap_8
XFILLER_61_221 VDD VSS sg13cmos5l_decap_4
XFILLER_62_755 VDD VSS sg13cmos5l_fill_2
XFILLER_99_4 VDD VSS sg13cmos5l_decap_8
X_4720_ _4785_/B _4720_/A _4730_/A VDD VSS sg13cmos5l_xor2_1
X_4651_ _4695_/B _5080_/A _4651_/B VDD VSS sg13cmos5l_xnor2_1
Xinput20 input20/X bank_A_wdata[1] VDD VSS sg13cmos5l_buf_1
Xinput31 input31/X bank_A_wdata[2] VDD VSS sg13cmos5l_buf_1
X_7370_ _7370_/Y _7370_/A _7377_/B VDD VSS sg13cmos5l_nor2_1
X_4582_ _4627_/A _4534_/B _4534_/A _4581_/Y VDD VSS sg13cmos5l_a21oi_1
Xinput53 input53/X bank_B_wdata[12] VDD VSS sg13cmos5l_buf_1
Xinput42 _6187_/A bank_B_addr[0] VDD VSS sg13cmos5l_buf_1
Xinput64 input64/X bank_B_wdata[22] VDD VSS sg13cmos5l_buf_1
Xinput97 _7716_/D quant_cfg[25] VDD VSS sg13cmos5l_buf_1
Xinput86 _4494_/A quant_cfg[14] VDD VSS sg13cmos5l_buf_1
Xinput75 input75/X bank_B_wdata[3] VDD VSS sg13cmos5l_buf_1
X_6321_ _6483_/B _6354_/A _6355_/A _6548_/C VDD VSS sg13cmos5l_nor3_1
X_6252_ _6802_/A _6704_/A _6268_/A VDD VSS sg13cmos5l_xnor2_1
X_5203_ _5572_/A _5203_/A VDD VSS sg13cmos5l_buf_1
X_6183_ _6183_/Y _6183_/A VDD VSS sg13cmos5l_inv_1
X_5134_ _5135_/B _5000_/X _4876_/X _4932_/X _4877_/X VDD VSS sg13cmos5l_a22oi_1
XFILLER_38_741 VDD VSS sg13cmos5l_decap_8
XFILLER_57_549 VDD VSS sg13cmos5l_fill_2
X_5065_ _5123_/A _5133_/A _5065_/B VDD VSS sg13cmos5l_xnor2_1
X_4016_ _4016_/Y _5811_/B _4043_/A VDD VSS sg13cmos5l_nand2_1
XFILLER_37_273 VDD VSS sg13cmos5l_decap_8
XFILLER_37_262 VDD VSS sg13cmos5l_fill_2
XFILLER_53_722 VDD VSS sg13cmos5l_decap_4
XFILLER_80_574 VDD VSS sg13cmos5l_decap_8
X_5967_ _5967_/Y _5967_/A _5967_/B VDD VSS sg13cmos5l_nand2_1
XFILLER_52_276 VDD VSS sg13cmos5l_decap_8
XFILLER_80_596 VDD VSS sg13cmos5l_decap_8
X_7706_ _7706_/Q _7724_/CLK _7706_/D fanout382/X VDD VSS sg13cmos5l_dfrbpq_1
X_4918_ _4962_/A _5048_/A _4981_/B VDD VSS sg13cmos5l_xnor2_1
X_5898_ _5898_/Y _6111_/A _5898_/B VDD VSS sg13cmos5l_nor2_1
X_7637_ _7722_/D _7637_/A _7658_/B VDD VSS sg13cmos5l_nand2_2
X_4849_ _7679_/D _4849_/A _4849_/B VDD VSS sg13cmos5l_xnor2_1
X_7568_ _7569_/D _7621_/A VDD VSS sg13cmos5l_inv_1
X_6519_ _6519_/Y _6519_/A _6518_/A VDD VSS sg13cmos5l_nor2b_1
X_7499_ _7624_/C _7497_/Y _7499_/B VDD VSS sg13cmos5l_nand2b_1
XFILLER_75_324 VDD VSS sg13cmos5l_decap_4
XFILLER_44_700 VDD VSS sg13cmos5l_decap_4
XFILLER_57_99 VDD VSS sg13cmos5l_fill_1
XFILLER_71_574 VDD VSS sg13cmos5l_fill_2
XFILLER_43_265 VDD VSS sg13cmos5l_fill_2
XFILLER_79_641 VDD VSS sg13cmos5l_fill_1
XFILLER_78_151 VDD VSS sg13cmos5l_decap_8
XFILLER_78_173 VDD VSS sg13cmos5l_decap_8
XFILLER_14_4 VDD VSS sg13cmos5l_decap_8
XFILLER_81_338 VDD VSS sg13cmos5l_decap_8
X_6870_ _6871_/B _6870_/A _6870_/B VDD VSS sg13cmos5l_nand2_1
X_5821_ _5821_/Y _5822_/B _5822_/A VDD VSS sg13cmos5l_nand2_1
XFILLER_35_777 VDD VSS sg13cmos5l_fill_1
XFILLER_62_585 VDD VSS sg13cmos5l_fill_1
XFILLER_50_747 VDD VSS sg13cmos5l_decap_8
X_5752_ _5772_/A _5752_/A _5752_/B VDD VSS sg13cmos5l_xor2_1
X_4703_ _4703_/Y _4703_/A _4703_/B VDD VSS sg13cmos5l_nor2_1
X_5683_ _5683_/X _5683_/A VDD VSS sg13cmos5l_buf_1
X_7422_ _7575_/B _7417_/B _7424_/A VDD VSS sg13cmos5l_nand2b_1
X_4634_ _4635_/B _5050_/B1 _4876_/A _4433_/X _4877_/A VDD VSS sg13cmos5l_a22oi_1
X_7353_ _7354_/A _7374_/B _7353_/B VDD VSS sg13cmos5l_nor2_1
X_4565_ _4566_/B _4738_/B1 _5118_/A _4675_/B1 _5119_/A VDD VSS sg13cmos5l_a22oi_1
X_6304_ _6314_/A _6576_/A _6602_/B VDD VSS sg13cmos5l_nor2_1
X_7284_ _7284_/Y _7284_/A VDD VSS sg13cmos5l_inv_1
X_4496_ _4561_/A _4496_/A VDD VSS sg13cmos5l_inv_1
X_6235_ _6254_/A _6720_/A VDD VSS sg13cmos5l_inv_4
X_6166_ _6175_/A _6166_/A _6147_/A VDD VSS sg13cmos5l_nor2b_1
X_6097_ _6129_/A _6097_/A _6070_/A VDD VSS sg13cmos5l_nor2b_1
X_5117_ _5177_/S _5178_/B1 _5309_/A _5117_/B1 _5683_/A VDD VSS sg13cmos5l_a22oi_1
XFILLER_57_313 VDD VSS sg13cmos5l_fill_1
X_5048_ _5095_/A _5048_/A _5171_/B VDD VSS sg13cmos5l_xnor2_1
XFILLER_45_508 VDD VSS sg13cmos5l_decap_8
XFILLER_45_519 VDD VSS sg13cmos5l_fill_1
XFILLER_73_839 VDD VSS sg13cmos5l_decap_8
XFILLER_66_891 VDD VSS sg13cmos5l_fill_1
XFILLER_38_582 VDD VSS sg13cmos5l_fill_1
XFILLER_80_360 VDD VSS sg13cmos5l_decap_8
XFILLER_53_563 VDD VSS sg13cmos5l_fill_1
X_6999_ _7233_/C _7154_/A _7162_/B VDD VSS sg13cmos5l_nand2_1
XFILLER_40_246 VDD VSS sg13cmos5l_decap_8
Xrebuffer720 _7522_/A1 _7342_/A VDD VSS sg13cmos5l_buf_1
Xrebuffer742 rebuffer742/X rebuffer743/X VDD VSS sg13cmos5l_buf_1
Xrebuffer731 rebuffer731/X rebuffer732/X VDD VSS sg13cmos5l_buf_1
Xrebuffer764 _7567_/B _7393_/A VDD VSS sg13cmos5l_buf_1
Xrebuffer753 _6771_/B _6583_/A VDD VSS sg13cmos5l_buf_1
Xrebuffer775 _6977_/B _6244_/A VDD VSS sg13cmos5l_buf_1
XFILLER_75_110 VDD VSS sg13cmos5l_decap_8
XFILLER_48_335 VDD VSS sg13cmos5l_fill_1
XFILLER_36_508 VDD VSS sg13cmos5l_decap_8
XFILLER_36_519 VDD VSS sg13cmos5l_fill_1
XFILLER_63_338 VDD VSS sg13cmos5l_fill_2
XFILLER_71_382 VDD VSS sg13cmos5l_fill_2
XFILLER_44_596 VDD VSS sg13cmos5l_fill_2
X_4350_ _4350_/Y _4350_/A VDD VSS sg13cmos5l_inv_1
X_4281_ _4282_/B _4319_/A _4319_/B VDD VSS sg13cmos5l_xor2_1
XFILLER_79_460 VDD VSS sg13cmos5l_decap_4
X_6020_ _6067_/A _5993_/B _5993_/A _6019_/Y VDD VSS sg13cmos5l_a21oi_1
XFILLER_79_493 VDD VSS sg13cmos5l_fill_1
XFILLER_67_611 VDD VSS sg13cmos5l_decap_8
XFILLER_82_603 VDD VSS sg13cmos5l_fill_2
XFILLER_39_379 VDD VSS sg13cmos5l_fill_2
XFILLER_82_669 VDD VSS sg13cmos5l_decap_4
XFILLER_81_135 VDD VSS sg13cmos5l_decap_8
X_6922_ _6922_/Y _6922_/A _6937_/A VDD VSS sg13cmos5l_nand2_1
XFILLER_35_552 VDD VSS sg13cmos5l_decap_4
X_6853_ _6955_/A _6853_/A _6438_/B VDD VSS sg13cmos5l_nor2b_1
XFILLER_63_883 VDD VSS sg13cmos5l_decap_8
X_5804_ _5863_/A _5870_/A _5804_/B VDD VSS sg13cmos5l_xnor2_1
XFILLER_63_894 VDD VSS sg13cmos5l_fill_1
X_3996_ _3997_/A _5811_/B _5810_/A VDD VSS sg13cmos5l_nor2b_1
X_6784_ _6894_/A _6784_/A _7059_/A VDD VSS sg13cmos5l_nand2_1
X_5735_ _7693_/D _5735_/A _5735_/B VDD VSS sg13cmos5l_xnor2_1
X_5666_ _5668_/A _5667_/A _5667_/C _5667_/B VDD VSS sg13cmos5l_a21oi_1
X_4617_ _4718_/A _4571_/B _4571_/A _4616_/X VDD VSS sg13cmos5l_a21oi_1
X_7405_ _7405_/Y _7300_/Y _7313_/X _7377_/B VDD VSS sg13cmos5l_a21oi_1
X_5597_ _5598_/B _5597_/A _5597_/B VDD VSS sg13cmos5l_nand2_1
X_7336_ _7525_/B _7336_/A _7347_/B VDD VSS sg13cmos5l_nand2_1
X_4548_ _7674_/D _4548_/A _4548_/B_N VDD VSS sg13cmos5l_nor2b_1
X_7267_ _7267_/Y _7280_/A1 _7263_/Y _7266_/Y VDD VSS sg13cmos5l_o21ai_1
X_4479_ _4547_/A _4479_/A _4479_/B _4479_/C VDD VSS sg13cmos5l_nand3_1
X_6218_ _6218_/Y _6219_/A _6192_/Y _6217_/Y VDD VSS sg13cmos5l_o21ai_1
X_7198_ _7198_/Y _7274_/A _7197_/Y _7290_/A VDD VSS sg13cmos5l_a21oi_1
X_6149_ _6149_/Y _6149_/A _6149_/B VDD VSS sg13cmos5l_nand2_1
XFILLER_38_46 VDD VSS sg13cmos5l_decap_8
XFILLER_39_880 VDD VSS sg13cmos5l_decap_8
XFILLER_45_316 VDD VSS sg13cmos5l_fill_2
XFILLER_45_305 VDD VSS sg13cmos5l_decap_8
XFILLER_46_839 VDD VSS sg13cmos5l_fill_2
XFILLER_57_176 VDD VSS sg13cmos5l_decap_8
XFILLER_72_124 VDD VSS sg13cmos5l_decap_8
XFILLER_54_12 VDD VSS sg13cmos5l_fill_2
XFILLER_81_680 VDD VSS sg13cmos5l_decap_8
XFILLER_54_78 VDD VSS sg13cmos5l_decap_8
XFILLER_79_20 VDD VSS sg13cmos5l_fill_1
XFILLER_79_64 VDD VSS sg13cmos5l_decap_4
Xbank_A_sram.gen_ihp_256x32.u_sram_256x32_410 bank_A_sram.gen_ihp_256x32.u_sram_256x32_410/L_LO
+ VDD VSS sg13cmos5l_tielo
XFILLER_49_600 VDD VSS sg13cmos5l_fill_1
Xbank_A_sram.gen_ihp_256x32.u_sram_256x32_443 bank_A_sram.gen_ihp_256x32.u_sram_256x32_443/L_LO
+ VDD VSS sg13cmos5l_tielo
Xbank_A_sram.gen_ihp_256x32.u_sram_256x32_454 bank_A_sram.gen_ihp_256x32.u_sram_256x32_454/L_LO
+ VDD VSS sg13cmos5l_tielo
Xbank_A_sram.gen_ihp_256x32.u_sram_256x32_421 bank_A_sram.gen_ihp_256x32.u_sram_256x32_421/L_LO
+ VDD VSS sg13cmos5l_tielo
Xbank_A_sram.gen_ihp_256x32.u_sram_256x32_432 bank_A_sram.gen_ihp_256x32.u_sram_256x32_432/L_LO
+ VDD VSS sg13cmos5l_tielo
XFILLER_49_633 VDD VSS sg13cmos5l_fill_1
Xbank_A_sram.gen_ihp_256x32.u_sram_256x32_465 bank_A_sram.gen_ihp_256x32.u_sram_256x32_465/L_LO
+ VDD VSS sg13cmos5l_tielo
XFILLER_48_143 VDD VSS sg13cmos5l_fill_1
XFILLER_49_644 VDD VSS sg13cmos5l_fill_1
XFILLER_76_474 VDD VSS sg13cmos5l_fill_2
XFILLER_36_305 VDD VSS sg13cmos5l_decap_8
XFILLER_48_154 VDD VSS sg13cmos5l_decap_8
XFILLER_63_168 VDD VSS sg13cmos5l_fill_1
Xbank_B_sram.gen_ihp_256x32.u_sram_256x32_480 bank_B_sram.gen_ihp_256x32.u_sram_256x32_480/L_LO
+ VDD VSS sg13cmos5l_tielo
Xbank_B_sram.gen_ihp_256x32.u_sram_256x32_491 bank_B_sram.gen_ihp_256x32.u_sram_256x32_491/L_LO
+ VDD VSS sg13cmos5l_tielo
XFILLER_81_4 VDD VSS sg13cmos5l_fill_1
X_5520_ _5520_/Y _5520_/A VDD VSS sg13cmos5l_inv_1
X_5451_ _5452_/B _5497_/A _5497_/B VDD VSS sg13cmos5l_xor2_1
XFILLER_67_2 VDD VSS sg13cmos5l_fill_1
X_5382_ _5382_/X _5382_/A VDD VSS sg13cmos5l_buf_1
X_4402_ _4403_/B _4461_/B _4461_/A VDD VSS sg13cmos5l_xor2_1
X_4333_ _4399_/A _4333_/A _4333_/B VDD VSS sg13cmos5l_xor2_1
X_7121_ _7123_/B _7150_/B _7121_/B VDD VSS sg13cmos5l_xor2_1
Xfanout229 _7394_/A2 _7313_/X VDD VSS sg13cmos5l_buf_1
X_4264_ _4305_/A _4312_/A _4264_/B VDD VSS sg13cmos5l_xnor2_1
X_7052_ _7052_/X _7052_/A _7072_/B VDD VSS sg13cmos5l_and2_1
Xfanout207 _7246_/A _7261_/A VDD VSS sg13cmos5l_buf_1
Xfanout218 _5569_/A _4997_/X VDD VSS sg13cmos5l_buf_1
X_6003_ _6007_/A _6073_/A VDD VSS sg13cmos5l_inv_1
X_4195_ _4252_/A _4508_/A _4251_/B VDD VSS sg13cmos5l_xnor2_1
XFILLER_55_625 VDD VSS sg13cmos5l_decap_4
XFILLER_82_455 VDD VSS sg13cmos5l_decap_8
X_6905_ _6906_/B _6741_/Y _6910_/S _6904_/Y VDD VSS sg13cmos5l_a21oi_1
XFILLER_36_872 VDD VSS sg13cmos5l_decap_8
XFILLER_35_382 VDD VSS sg13cmos5l_decap_4
X_6836_ _6838_/A _6836_/A _6836_/B VDD VSS sg13cmos5l_nand2_1
XFILLER_51_853 VDD VSS sg13cmos5l_fill_1
X_6767_ _7001_/A _6764_/Y _6910_/S _6766_/X VDD VSS sg13cmos5l_a21oi_1
XFILLER_50_363 VDD VSS sg13cmos5l_decap_4
X_3979_ _3980_/A _5645_/A _3947_/A _3978_/Y VDD VSS sg13cmos5l_o21ai_1
X_5718_ _5719_/B _5718_/A _5769_/A VDD VSS sg13cmos5l_xnor2_1
X_6698_ _6699_/A _7111_/A _6698_/B VDD VSS sg13cmos5l_nor2_1
X_5649_ _5652_/A _5649_/A _5649_/B VDD VSS sg13cmos5l_xor2_1
XFILLER_40_69 VDD VSS sg13cmos5l_decap_8
X_7319_ _7320_/A _7327_/A _7319_/B VDD VSS sg13cmos5l_nor2_1
XFILLER_49_23 VDD VSS sg13cmos5l_fill_2
XFILLER_78_739 VDD VSS sg13cmos5l_decap_8
XFILLER_1_19 VDD VSS sg13cmos5l_decap_8
XFILLER_58_474 VDD VSS sg13cmos5l_fill_1
XFILLER_45_124 VDD VSS sg13cmos5l_decap_8
XFILLER_45_113 VDD VSS sg13cmos5l_decap_4
XFILLER_41_341 VDD VSS sg13cmos5l_decap_8
XFILLER_42_842 VDD VSS sg13cmos5l_fill_1
XFILLER_60_149 VDD VSS sg13cmos5l_decap_8
XFILLER_69_706 VDD VSS sg13cmos5l_decap_4
XFILLER_49_474 VDD VSS sg13cmos5l_fill_1
Xinput7 input7/X bank_A_addr[6] VDD VSS sg13cmos5l_buf_1
XFILLER_36_102 VDD VSS sg13cmos5l_decap_8
XFILLER_64_433 VDD VSS sg13cmos5l_fill_1
X_4951_ _5007_/B _5080_/A _4951_/B VDD VSS sg13cmos5l_xnor2_1
XFILLER_36_179 VDD VSS sg13cmos5l_decap_8
XFILLER_52_628 VDD VSS sg13cmos5l_decap_8
X_4882_ _4882_/Y _4882_/A _4882_/B VDD VSS sg13cmos5l_nor2_1
X_7670_ _7670_/Q clkload6/A _7670_/D fanout387/X VDD VSS sg13cmos5l_dfrbpq_1
X_6621_ _6631_/B _6621_/A _6621_/B VDD VSS sg13cmos5l_nor2_1
XFILLER_60_694 VDD VSS sg13cmos5l_decap_4
XFILLER_72_0 VDD VSS sg13cmos5l_fill_1
X_6552_ _6861_/B _6552_/A _7689_/Q _6589_/A VDD VSS sg13cmos5l_nand3_1
X_6483_ _6485_/A _6541_/A _6483_/B VDD VSS sg13cmos5l_nand2_1
X_5503_ _5504_/B _5792_/B1 _5568_/A _5745_/B1 _5569_/A VDD VSS sg13cmos5l_a22oi_1
XFILLER_10_28 VDD VSS sg13cmos5l_fill_1
X_5434_ _5434_/X _5434_/A _5434_/B VDD VSS sg13cmos5l_and2_1
X_5365_ _5416_/A _5365_/A _5365_/B VDD VSS sg13cmos5l_nand2_1
X_7104_ _7104_/Y _7262_/A _7153_/A _7103_/X VDD VSS sg13cmos5l_a21oi_1
X_5296_ _5359_/A _5227_/B _5227_/A _5295_/Y VDD VSS sg13cmos5l_a21oi_1
X_4316_ _4369_/B _4316_/A _4316_/B VDD VSS sg13cmos5l_xnor2_1
X_4247_ _7669_/D _4247_/A _4351_/A VDD VSS sg13cmos5l_nor2_1
X_7035_ _7170_/A _6845_/B _7032_/B _7034_/X VDD VSS sg13cmos5l_a21oi_1
X_4178_ _4179_/B _4178_/A _4178_/B VDD VSS sg13cmos5l_xor2_1
XFILLER_68_783 VDD VSS sg13cmos5l_fill_1
XFILLER_55_422 VDD VSS sg13cmos5l_decap_8
XFILLER_55_433 VDD VSS sg13cmos5l_fill_1
XFILLER_71_904 VDD VSS sg13cmos5l_fill_2
XFILLER_82_274 VDD VSS sg13cmos5l_decap_8
XFILLER_51_650 VDD VSS sg13cmos5l_fill_2
X_6819_ _7114_/A _7004_/A _7018_/A _6818_/Y VDD VSS sg13cmos5l_o21ai_1
XFILLER_73_230 VDD VSS sg13cmos5l_fill_2
XFILLER_46_466 VDD VSS sg13cmos5l_fill_1
XFILLER_62_926 VDD VSS sg13cmos5l_decap_8
XFILLER_74_797 VDD VSS sg13cmos5l_fill_1
XFILLER_73_285 VDD VSS sg13cmos5l_decap_8
XFILLER_61_425 VDD VSS sg13cmos5l_decap_8
XFILLER_42_672 VDD VSS sg13cmos5l_decap_8
X_5150_ _5197_/B _5586_/A _5150_/B VDD VSS sg13cmos5l_xnor2_1
X_4101_ _6181_/A _4108_/C _4108_/B VDD VSS sg13cmos5l_xnor2_1
X_5081_ _5081_/X _5081_/A VDD VSS sg13cmos5l_buf_1
X_4032_ _4042_/B _4032_/A _4032_/B VDD VSS sg13cmos5l_xor2_1
XFILLER_65_720 VDD VSS sg13cmos5l_fill_2
X_5983_ _6033_/B _6057_/A _5983_/B VDD VSS sg13cmos5l_xnor2_1
XFILLER_64_285 VDD VSS sg13cmos5l_decap_8
X_7722_ _7722_/Q _7728_/CLK _7722_/D fanout391/X VDD VSS sg13cmos5l_dfrbpq_1
X_4934_ _4990_/A _5442_/A _4934_/B VDD VSS sg13cmos5l_xnor2_1
XANTENNA_12 _4169_/A VDD VSS sg13cmos5l_antennanp
XANTENNA_23 _7707_/D VDD VSS sg13cmos5l_antennanp
X_7653_ _7654_/A _7657_/A _7653_/B VDD VSS sg13cmos5l_nand2_2
X_4865_ _4866_/B _4865_/A _4916_/A VDD VSS sg13cmos5l_xnor2_1
X_6604_ _6614_/A _6605_/B _6605_/A VDD VSS sg13cmos5l_nor2_2
X_4796_ _4796_/Y _4796_/A _4744_/A VDD VSS sg13cmos5l_nor2b_1
X_7584_ _7588_/A _7584_/A _7624_/C _7624_/B _7624_/A VDD VSS sg13cmos5l_nor4_2
X_6535_ _6537_/A _6542_/A _6542_/B VDD VSS sg13cmos5l_xnor2_1
X_6466_ _6468_/B _6466_/A VDD VSS sg13cmos5l_inv_1
Xoutput130 bank_A_rdata[22] _4943_/A VDD VSS sg13cmos5l_buf_1
Xoutput141 bank_A_rdata[3] _3973_/A VDD VSS sg13cmos5l_buf_1
X_5417_ _5419_/A _5417_/A _5355_/A VDD VSS sg13cmos5l_nor2b_1
Xoutput152 bank_B_rdata[13] output152/A VDD VSS sg13cmos5l_buf_1
X_6397_ _6541_/B _6915_/A _6516_/A _6548_/C VDD VSS sg13cmos5l_nor3_1
Xoutput163 bank_B_rdata[23] output163/A VDD VSS sg13cmos5l_buf_1
Xoutput174 bank_B_rdata[4] _6221_/B VDD VSS sg13cmos5l_buf_1
X_5348_ _5349_/B _5346_/Y _5285_/B _5347_/Y VDD VSS sg13cmos5l_o21ai_1
X_5279_ _5328_/B _5586_/A _5279_/B VDD VSS sg13cmos5l_xnor2_1
X_7018_ _7018_/Y _7018_/A _7018_/B VDD VSS sg13cmos5l_nand2_1
XFILLER_68_591 VDD VSS sg13cmos5l_decap_4
XFILLER_46_13 VDD VSS sg13cmos5l_fill_1
XFILLER_46_57 VDD VSS sg13cmos5l_decap_8
XFILLER_71_723 VDD VSS sg13cmos5l_fill_2
XFILLER_70_211 VDD VSS sg13cmos5l_fill_1
XFILLER_70_200 VDD VSS sg13cmos5l_decap_8
XFILLER_43_425 VDD VSS sg13cmos5l_decap_4
XFILLER_55_285 VDD VSS sg13cmos5l_fill_1
XFILLER_55_296 VDD VSS sg13cmos5l_fill_1
XFILLER_43_469 VDD VSS sg13cmos5l_fill_1
XFILLER_62_23 VDD VSS sg13cmos5l_decap_8
XFILLER_62_67 VDD VSS sg13cmos5l_fill_1
XFILLER_62_89 VDD VSS sg13cmos5l_decap_8
XFILLER_78_311 VDD VSS sg13cmos5l_decap_8
Xfanout390 fanout390/X fanout391/X VDD VSS sg13cmos5l_buf_1
XFILLER_61_211 VDD VSS sg13cmos5l_decap_4
XFILLER_61_200 VDD VSS sg13cmos5l_fill_1
XFILLER_61_233 VDD VSS sg13cmos5l_decap_4
X_4650_ _4651_/B _4872_/A _5081_/A _4811_/A _5082_/A VDD VSS sg13cmos5l_a22oi_1
Xinput21 input21/X bank_A_wdata[20] VDD VSS sg13cmos5l_buf_1
Xinput10 input10/X bank_A_wdata[10] VDD VSS sg13cmos5l_buf_1
Xinput32 input32/X bank_A_wdata[30] VDD VSS sg13cmos5l_buf_1
X_6320_ _6791_/B _6320_/A _6320_/B VDD VSS sg13cmos5l_nand2_2
X_4581_ _4581_/Y _4581_/A _4581_/B VDD VSS sg13cmos5l_nor2_1
Xinput54 input54/X bank_B_wdata[13] VDD VSS sg13cmos5l_buf_1
Xinput43 _6190_/B bank_B_addr[1] VDD VSS sg13cmos5l_buf_1
Xinput98 _7717_/D quant_cfg[26] VDD VSS sg13cmos5l_buf_1
Xinput87 _4494_/B quant_cfg[15] VDD VSS sg13cmos5l_buf_1
Xinput76 input76/X bank_B_wdata[4] VDD VSS sg13cmos5l_buf_1
Xinput65 input65/X bank_B_wdata[23] VDD VSS sg13cmos5l_buf_1
X_6251_ _6251_/Y _6277_/A _6561_/B _7274_/A _6565_/C VDD VSS sg13cmos5l_nand4_1
X_6182_ _7665_/D _6182_/A _6182_/B VDD VSS sg13cmos5l_xnor2_1
X_5202_ _5212_/A _5331_/A _5202_/B VDD VSS sg13cmos5l_xnor2_1
X_5133_ _5182_/A _5133_/A _5133_/B VDD VSS sg13cmos5l_xnor2_1
X_5064_ _5065_/B _5622_/B1 _5258_/A _5557_/B1 _5259_/A VDD VSS sg13cmos5l_a22oi_1
X_4015_ _4040_/B _4015_/A _4015_/B VDD VSS sg13cmos5l_nand2_2
XFILLER_80_553 VDD VSS sg13cmos5l_decap_8
XFILLER_52_244 VDD VSS sg13cmos5l_fill_1
XFILLER_40_406 VDD VSS sg13cmos5l_fill_2
X_5966_ _6015_/B _6042_/A _5966_/B VDD VSS sg13cmos5l_xnor2_1
X_5897_ _5897_/Y _5897_/A _5897_/B VDD VSS sg13cmos5l_nand2_1
X_7705_ _7705_/Q clkload2/A _7705_/D fanout393/X VDD VSS sg13cmos5l_dfrbpq_1
X_4917_ _4981_/B _4866_/B _4866_/A _4916_/Y VDD VSS sg13cmos5l_a21oi_1
X_7636_ _7637_/A _7657_/A _7636_/B VDD VSS sg13cmos5l_nand2_2
X_4848_ _4849_/B _4846_/Y _4848_/B VDD VSS sg13cmos5l_nand2b_1
X_7567_ _7621_/A _7567_/A _7567_/B VDD VSS sg13cmos5l_xnor2_1
X_4779_ _4780_/B _4711_/A _4779_/B VDD VSS sg13cmos5l_nand2b_1
X_6518_ _6534_/A _6518_/A _6518_/B _6518_/C VDD VSS sg13cmos5l_nor3_2
X_7498_ _7499_/B _7498_/A _7498_/B _7574_/B VDD VSS sg13cmos5l_nand3_1
X_6449_ _6451_/A _6457_/C _6457_/A VDD VSS sg13cmos5l_xnor2_1
XFILLER_75_314 VDD VSS sg13cmos5l_fill_2
XFILLER_57_89 VDD VSS sg13cmos5l_decap_4
XFILLER_56_583 VDD VSS sg13cmos5l_decap_4
XFILLER_43_288 VDD VSS sg13cmos5l_fill_1
XFILLER_67_804 VDD VSS sg13cmos5l_decap_4
XFILLER_78_185 VDD VSS sg13cmos5l_decap_8
XFILLER_67_837 VDD VSS sg13cmos5l_decap_8
XFILLER_66_314 VDD VSS sg13cmos5l_decap_8
XFILLER_81_317 VDD VSS sg13cmos5l_decap_8
XFILLER_35_767 VDD VSS sg13cmos5l_fill_2
X_5820_ _5850_/B _5854_/A _5820_/B VDD VSS sg13cmos5l_xnor2_1
X_5751_ _5752_/B _5751_/A _5789_/A VDD VSS sg13cmos5l_xnor2_1
X_4702_ _4703_/B _5014_/A _4947_/B _4702_/C VDD VSS sg13cmos5l_nor3_1
X_7421_ _7574_/A _7421_/A VDD VSS sg13cmos5l_inv_1
X_5682_ _5693_/A _5625_/B _5415_/A _5682_/S VDD VSS sg13cmos5l_mux2_1
X_4633_ _4680_/A _4871_/A _4633_/B VDD VSS sg13cmos5l_xnor2_1
X_7352_ _7355_/B _7352_/A _7360_/A VDD VSS sg13cmos5l_xnor2_1
X_4564_ _4564_/X _4564_/A VDD VSS sg13cmos5l_buf_1
X_6303_ _6602_/B _6303_/A _6465_/B VDD VSS sg13cmos5l_nand2_1
X_7283_ _7284_/A _7152_/Y _7294_/B _7182_/A VDD VSS sg13cmos5l_a21oi_1
X_6234_ _6951_/A _7709_/Q VDD VSS sg13cmos5l_buf_8
X_4495_ _4496_/A _4495_/A _4495_/B VDD VSS sg13cmos5l_nand2_1
X_6165_ _6175_/C _6165_/A _6173_/B VDD VSS sg13cmos5l_xnor2_1
X_6096_ _6129_/B _6096_/A _6096_/B VDD VSS sg13cmos5l_xnor2_1
X_5116_ _5116_/X _5116_/A VDD VSS sg13cmos5l_buf_1
XFILLER_27_15 VDD VSS sg13cmos5l_decap_8
X_5047_ _5171_/B _4993_/B _4993_/A _5046_/Y VDD VSS sg13cmos5l_a21oi_1
XFILLER_73_829 VDD VSS sg13cmos5l_decap_4
X_6998_ _7154_/A _6728_/A _7071_/B _6997_/Y VDD VSS sg13cmos5l_a21oi_1
XFILLER_40_225 VDD VSS sg13cmos5l_decap_8
X_5949_ _5984_/S _5985_/B1 _6114_/A _5949_/B1 _6026_/B2 VDD VSS sg13cmos5l_a22oi_1
X_7619_ _7620_/D _7619_/A _7619_/B _7619_/C _7619_/D VDD VSS sg13cmos5l_and4_1
Xrebuffer721 _7655_/A1 _7177_/A VDD VSS sg13cmos5l_buf_1
Xrebuffer732 rebuffer732/X rebuffer733/X VDD VSS sg13cmos5l_buf_1
Xrebuffer710 rebuffer710/X rebuffer711/X VDD VSS sg13cmos5l_buf_1
Xrebuffer754 _7529_/B _7317_/A VDD VSS sg13cmos5l_buf_1
Xrebuffer743 rebuffer743/X rebuffer744/X VDD VSS sg13cmos5l_buf_1
Xrebuffer776 _6376_/A _6244_/A VDD VSS sg13cmos5l_buf_1
Xrebuffer765 _6698_/B _6241_/A VDD VSS sg13cmos5l_buf_1
XFILLER_76_645 VDD VSS sg13cmos5l_decap_4
XFILLER_64_818 VDD VSS sg13cmos5l_decap_4
XFILLER_75_188 VDD VSS sg13cmos5l_decap_8
XFILLER_75_155 VDD VSS sg13cmos5l_fill_1
XFILLER_63_306 VDD VSS sg13cmos5l_decap_4
XFILLER_75_199 VDD VSS sg13cmos5l_fill_1
XFILLER_83_8 VDD VSS sg13cmos5l_decap_8
X_4280_ _4319_/B _4528_/A _4280_/B VDD VSS sg13cmos5l_xnor2_1
XFILLER_66_111 VDD VSS sg13cmos5l_decap_4
XFILLER_39_336 VDD VSS sg13cmos5l_fill_2
XFILLER_82_659 VDD VSS sg13cmos5l_fill_2
XFILLER_81_114 VDD VSS sg13cmos5l_decap_8
X_6921_ _6922_/A _6921_/A VDD VSS sg13cmos5l_inv_1
XFILLER_35_575 VDD VSS sg13cmos5l_decap_8
X_6852_ _6853_/A _6852_/A1 _6820_/B _6436_/B VDD VSS sg13cmos5l_a21oi_1
XFILLER_63_862 VDD VSS sg13cmos5l_decap_8
X_5803_ _5804_/B _5755_/X _5869_/A2 _5712_/X _5869_/B2 VDD VSS sg13cmos5l_a22oi_1
XFILLER_35_586 VDD VSS sg13cmos5l_decap_4
X_3995_ _5810_/A _5645_/A _3995_/B VDD VSS sg13cmos5l_nand2_1
X_6783_ _7059_/A _6783_/A VDD VSS sg13cmos5l_buf_2
X_5734_ _5735_/B _5736_/A _5736_/B VDD VSS sg13cmos5l_nand2_1
X_5665_ _5667_/C _5665_/A _5665_/B VDD VSS sg13cmos5l_nand2_1
X_4616_ _4616_/X _4616_/A _4616_/B VDD VSS sg13cmos5l_and2_1
X_7404_ _7404_/X _7404_/A VDD VSS sg13cmos5l_buf_1
X_7335_ _7524_/B _7335_/A _7374_/B VDD VSS sg13cmos5l_nand2_1
X_5596_ _5597_/B _5528_/A _5596_/B VDD VSS sg13cmos5l_nand2b_1
X_4547_ _4547_/Y _4547_/A _4547_/B _4547_/C VDD VSS sg13cmos5l_nand3_1
X_7266_ _7266_/Y _7294_/B _7103_/A _7265_/Y VDD VSS sg13cmos5l_o21ai_1
X_4478_ _7673_/D _4478_/A _4478_/B VDD VSS sg13cmos5l_xnor2_1
X_6217_ _6217_/Y _6219_/A _6217_/B VDD VSS sg13cmos5l_nand2_1
XFILLER_58_601 VDD VSS sg13cmos5l_fill_1
X_7197_ _7197_/Y _7186_/Y _7190_/Y _7265_/A _7196_/Y VDD VSS sg13cmos5l_a22oi_1
X_6148_ _6150_/A _6149_/B _6149_/A VDD VSS sg13cmos5l_nor2_1
XFILLER_38_25 VDD VSS sg13cmos5l_decap_8
XFILLER_57_133 VDD VSS sg13cmos5l_decap_4
X_6079_ _6079_/Y _6079_/A _6063_/A VDD VSS sg13cmos5l_nor2b_1
XFILLER_54_35 VDD VSS sg13cmos5l_decap_8
XFILLER_54_862 VDD VSS sg13cmos5l_decap_8
XFILLER_70_12 VDD VSS sg13cmos5l_fill_1
XFILLER_79_32 VDD VSS sg13cmos5l_decap_8
XFILLER_79_87 VDD VSS sg13cmos5l_fill_2
Xbank_A_sram.gen_ihp_256x32.u_sram_256x32_411 bank_A_sram.gen_ihp_256x32.u_sram_256x32_411/L_LO
+ VDD VSS sg13cmos5l_tielo
Xbank_A_sram.gen_ihp_256x32.u_sram_256x32_400 bank_A_sram.gen_ihp_256x32.u_sram_256x32_400/L_LO
+ VDD VSS sg13cmos5l_tielo
XFILLER_79_98 VDD VSS sg13cmos5l_fill_1
Xbank_A_sram.gen_ihp_256x32.u_sram_256x32_444 bank_A_sram.gen_ihp_256x32.u_sram_256x32_444/L_LO
+ VDD VSS sg13cmos5l_tielo
Xbank_A_sram.gen_ihp_256x32.u_sram_256x32_422 bank_A_sram.gen_ihp_256x32.u_sram_256x32_422/L_LO
+ VDD VSS sg13cmos5l_tielo
Xbank_A_sram.gen_ihp_256x32.u_sram_256x32_433 bank_A_sram.gen_ihp_256x32.u_sram_256x32_433/L_LO
+ VDD VSS sg13cmos5l_tielo
XFILLER_49_612 VDD VSS sg13cmos5l_decap_8
Xbank_A_sram.gen_ihp_256x32.u_sram_256x32_466 bank_A_sram.gen_ihp_256x32.u_sram_256x32_466/L_LO
+ VDD VSS sg13cmos5l_tielo
Xbank_A_sram.gen_ihp_256x32.u_sram_256x32_455 bank_A_sram.gen_ihp_256x32.u_sram_256x32_455/L_LO
+ VDD VSS sg13cmos5l_tielo
XFILLER_48_166 VDD VSS sg13cmos5l_decap_4
XFILLER_64_648 VDD VSS sg13cmos5l_fill_2
XFILLER_45_873 VDD VSS sg13cmos5l_decap_8
XFILLER_63_147 VDD VSS sg13cmos5l_fill_1
XFILLER_60_832 VDD VSS sg13cmos5l_fill_2
Xbank_B_sram.gen_ihp_256x32.u_sram_256x32_481 bank_B_sram.gen_ihp_256x32.u_sram_256x32_481/L_LO
+ VDD VSS sg13cmos5l_tielo
Xbank_B_sram.gen_ihp_256x32.u_sram_256x32_492 bank_B_sram.gen_ihp_256x32.u_sram_256x32_492/L_LO
+ VDD VSS sg13cmos5l_tielo
XFILLER_60_843 VDD VSS sg13cmos5l_decap_8
XFILLER_60_865 VDD VSS sg13cmos5l_decap_4
XFILLER_44_90 VDD VSS sg13cmos5l_fill_2
XFILLER_60_898 VDD VSS sg13cmos5l_decap_4
X_5450_ _5497_/B _5872_/A _5450_/B VDD VSS sg13cmos5l_xnor2_1
X_4401_ _4461_/A _4334_/A _4399_/Y _4400_/Y VDD VSS sg13cmos5l_o21ai_1
X_5381_ _5388_/A _5630_/A _5381_/B VDD VSS sg13cmos5l_xnor2_1
X_4332_ _4333_/B _4382_/A _4382_/B VDD VSS sg13cmos5l_xor2_1
X_7120_ _7121_/B _7289_/A _7104_/Y _7119_/Y VDD VSS sg13cmos5l_o21ai_1
Xfanout219 _5206_/B _5014_/B VDD VSS sg13cmos5l_buf_1
X_4263_ _4264_/B _4799_/B1 _4047_/X _4738_/B1 _4752_/A VDD VSS sg13cmos5l_a22oi_1
X_7051_ _7051_/X _7076_/B VDD VSS sg13cmos5l_buf_1
Xfanout208 _7248_/A _7179_/X VDD VSS sg13cmos5l_buf_1
XFILLER_68_932 VDD VSS sg13cmos5l_fill_2
XFILLER_68_921 VDD VSS sg13cmos5l_decap_8
X_6002_ _6073_/A _6004_/B _6004_/A VDD VSS sg13cmos5l_nor2_1
X_4194_ _4251_/B _4194_/A _4194_/B VDD VSS sg13cmos5l_nand2_1
XFILLER_67_420 VDD VSS sg13cmos5l_decap_8
XFILLER_67_464 VDD VSS sg13cmos5l_decap_4
XFILLER_55_604 VDD VSS sg13cmos5l_decap_8
XFILLER_55_637 VDD VSS sg13cmos5l_decap_8
XFILLER_70_607 VDD VSS sg13cmos5l_decap_4
X_6904_ _6904_/Y _6939_/A _6904_/B VDD VSS sg13cmos5l_nor2_1
XFILLER_36_851 VDD VSS sg13cmos5l_decap_8
XFILLER_35_372 VDD VSS sg13cmos5l_fill_2
XFILLER_63_670 VDD VSS sg13cmos5l_fill_1
XFILLER_24_16 VDD VSS sg13cmos5l_decap_8
XFILLER_24_27 VDD VSS sg13cmos5l_fill_2
X_6835_ _6941_/A _6835_/A _6835_/B VDD VSS sg13cmos5l_xnor2_1
X_3978_ _3978_/Y _5706_/B _5645_/A VDD VSS sg13cmos5l_nand2_1
X_6766_ _6766_/X _6766_/A _6960_/B VDD VSS sg13cmos5l_and2_1
XFILLER_51_887 VDD VSS sg13cmos5l_decap_8
X_5717_ _5769_/A _5710_/B _5646_/B _5716_/Y VDD VSS sg13cmos5l_a21oi_1
XFILLER_40_15 VDD VSS sg13cmos5l_decap_8
X_6697_ _7158_/A _6697_/A VDD VSS sg13cmos5l_buf_4
X_5648_ _5649_/B _5694_/A _5694_/B VDD VSS sg13cmos5l_xor2_1
XFILLER_40_48 VDD VSS sg13cmos5l_decap_8
X_5579_ _5579_/X _5579_/A _5579_/B VDD VSS sg13cmos5l_and2_1
X_7318_ _7318_/Y _7318_/A _7318_/B VDD VSS sg13cmos5l_nand2_2
XFILLER_78_718 VDD VSS sg13cmos5l_decap_8
X_7249_ _7250_/B _7261_/A _7249_/B VDD VSS sg13cmos5l_nor2_1
XFILLER_77_206 VDD VSS sg13cmos5l_fill_1
XFILLER_46_637 VDD VSS sg13cmos5l_decap_8
XFILLER_65_56 VDD VSS sg13cmos5l_decap_4
XFILLER_65_78 VDD VSS sg13cmos5l_fill_1
XFILLER_60_128 VDD VSS sg13cmos5l_fill_1
XFILLER_41_331 VDD VSS sg13cmos5l_fill_2
XFILLER_42_854 VDD VSS sg13cmos5l_fill_1
XFILLER_81_66 VDD VSS sg13cmos5l_decap_8
XFILLER_41_364 VDD VSS sg13cmos5l_decap_4
XFILLER_68_206 VDD VSS sg13cmos5l_fill_2
XFILLER_77_784 VDD VSS sg13cmos5l_decap_4
Xinput8 input8/X bank_A_addr[7] VDD VSS sg13cmos5l_buf_1
XFILLER_65_924 VDD VSS sg13cmos5l_decap_8
XFILLER_49_497 VDD VSS sg13cmos5l_fill_1
XFILLER_64_412 VDD VSS sg13cmos5l_decap_4
XFILLER_36_158 VDD VSS sg13cmos5l_decap_8
X_4950_ _4951_/B _5190_/A _5081_/A _5131_/A _5082_/A VDD VSS sg13cmos5l_a22oi_1
XFILLER_51_106 VDD VSS sg13cmos5l_fill_1
XFILLER_51_117 VDD VSS sg13cmos5l_fill_1
XFILLER_64_489 VDD VSS sg13cmos5l_fill_1
X_4881_ _4897_/A _4881_/A _4881_/B VDD VSS sg13cmos5l_xor2_1
X_6620_ _6627_/A _6620_/A _6620_/B VDD VSS sg13cmos5l_nand2_2
X_6551_ _6553_/A _6552_/A _6589_/A _7689_/Q VDD VSS sg13cmos5l_a21oi_1
X_5502_ _5528_/A _5468_/B _5468_/A _5501_/Y VDD VSS sg13cmos5l_a21oi_1
X_6482_ _6488_/A _6482_/A _6482_/B VDD VSS sg13cmos5l_nand2_2
X_5433_ _5436_/A _5492_/S _5433_/B VDD VSS sg13cmos5l_xnor2_1
X_5364_ _5365_/B _5364_/A _5364_/B VDD VSS sg13cmos5l_nand2_1
X_7103_ _7103_/X _7103_/A _7181_/A VDD VSS sg13cmos5l_and2_1
X_4315_ _4316_/B _4205_/X _4876_/A _4155_/X _4877_/A VDD VSS sg13cmos5l_a22oi_1
X_5295_ _5295_/Y _5295_/A _5295_/B VDD VSS sg13cmos5l_nor2_1
XFILLER_68_751 VDD VSS sg13cmos5l_decap_4
X_4246_ _4351_/A _4294_/B VDD VSS sg13cmos5l_inv_1
X_7034_ _7034_/X _7034_/A _7034_/B VDD VSS sg13cmos5l_and2_1
X_4177_ _4178_/B _4212_/A _4212_/B VDD VSS sg13cmos5l_xor2_1
XFILLER_68_762 VDD VSS sg13cmos5l_decap_8
XFILLER_67_261 VDD VSS sg13cmos5l_fill_2
XFILLER_55_412 VDD VSS sg13cmos5l_fill_2
XFILLER_82_242 VDD VSS sg13cmos5l_decap_4
XFILLER_35_15 VDD VSS sg13cmos5l_decap_8
XFILLER_55_456 VDD VSS sg13cmos5l_fill_2
XFILLER_70_415 VDD VSS sg13cmos5l_fill_1
XFILLER_42_128 VDD VSS sg13cmos5l_decap_4
XFILLER_35_180 VDD VSS sg13cmos5l_decap_8
XFILLER_51_640 VDD VSS sg13cmos5l_fill_2
X_6818_ _6818_/Y _7014_/B _6996_/A VDD VSS sg13cmos5l_nand2_1
XFILLER_50_161 VDD VSS sg13cmos5l_decap_4
X_6749_ _6751_/A _7004_/A _6739_/Y _6748_/Y VDD VSS sg13cmos5l_o21ai_1
XFILLER_4_4 VDD VSS sg13cmos5l_decap_4
XFILLER_76_66 VDD VSS sg13cmos5l_decap_8
XFILLER_76_44 VDD VSS sg13cmos5l_decap_4
XFILLER_47_913 VDD VSS sg13cmos5l_fill_1
XFILLER_59_784 VDD VSS sg13cmos5l_fill_1
XFILLER_61_404 VDD VSS sg13cmos5l_fill_1
XFILLER_61_459 VDD VSS sg13cmos5l_fill_1
XFILLER_41_161 VDD VSS sg13cmos5l_decap_4
XFILLER_41_80 VDD VSS sg13cmos5l_decap_8
XFILLER_69_504 VDD VSS sg13cmos5l_fill_1
X_4100_ _6182_/A _4100_/A _4100_/B VDD VSS sg13cmos5l_nor2_1
X_5080_ _5400_/A _5080_/A VDD VSS sg13cmos5l_buf_1
XFILLER_69_548 VDD VSS sg13cmos5l_decap_8
XFILLER_69_537 VDD VSS sg13cmos5l_fill_1
X_4031_ _4032_/B _4050_/A _4050_/B VDD VSS sg13cmos5l_xor2_1
XFILLER_38_913 VDD VSS sg13cmos5l_decap_8
XFILLER_77_592 VDD VSS sg13cmos5l_decap_8
XFILLER_49_261 VDD VSS sg13cmos5l_decap_4
XFILLER_65_743 VDD VSS sg13cmos5l_decap_8
XFILLER_64_242 VDD VSS sg13cmos5l_fill_1
X_5982_ _5983_/B _5982_/A _5982_/B VDD VSS sg13cmos5l_xnor2_1
X_7721_ _7721_/Q clkload3/A _7721_/D fanout383/X VDD VSS sg13cmos5l_dfrbpq_1
X_4933_ _4934_/B _5493_/B1 _4751_/X _5430_/B1 _4752_/X VDD VSS sg13cmos5l_a22oi_1
XANTENNA_13 input11/X VDD VSS sg13cmos5l_antennanp
X_7652_ _7653_/B _7652_/A _7652_/B VDD VSS sg13cmos5l_xnor2_1
X_4864_ _4916_/A _4817_/B _4817_/A _4863_/X VDD VSS sg13cmos5l_a21oi_1
XANTENNA_24 _7708_/D VDD VSS sg13cmos5l_antennanp
X_6603_ _6605_/A _6603_/A _6603_/B VDD VSS sg13cmos5l_nand2_1
X_4795_ _4852_/A _4781_/B _4781_/A _4794_/Y VDD VSS sg13cmos5l_a21o_1
X_7583_ _7624_/A _7583_/A _7583_/B VDD VSS sg13cmos5l_xnor2_1
X_6534_ _6542_/B _6534_/A _6534_/B VDD VSS sg13cmos5l_nand2_2
X_6465_ _6466_/A _6465_/A _6465_/B VDD VSS sg13cmos5l_nand2_1
X_5416_ _5420_/A _5416_/A _5481_/A VDD VSS sg13cmos5l_xnor2_1
Xoutput131 bank_A_rdata[23] _5011_/A VDD VSS sg13cmos5l_buf_1
Xoutput120 bank_A_rdata[13] _4386_/A VDD VSS sg13cmos5l_buf_1
Xoutput142 bank_A_rdata[4] _4001_/A VDD VSS sg13cmos5l_buf_1
X_6396_ _6404_/A _6396_/A _6396_/B VDD VSS sg13cmos5l_nand2_2
Xoutput164 bank_B_rdata[24] output164/A VDD VSS sg13cmos5l_buf_1
Xoutput175 bank_B_rdata[5] _6223_/B VDD VSS sg13cmos5l_buf_1
Xoutput153 bank_B_rdata[14] output153/A VDD VSS sg13cmos5l_buf_1
X_5347_ _5347_/Y _5284_/A _5347_/B VDD VSS sg13cmos5l_nand2b_1
X_5278_ _5279_/B _5505_/A _5081_/X _5443_/A _5082_/X VDD VSS sg13cmos5l_a22oi_1
XFILLER_75_518 VDD VSS sg13cmos5l_decap_4
X_4229_ _4250_/B _4252_/A _4229_/B VDD VSS sg13cmos5l_xnor2_1
X_7017_ _7237_/B _7013_/Y _7080_/A _7016_/Y VDD VSS sg13cmos5l_a21oi_1
XFILLER_75_529 VDD VSS sg13cmos5l_decap_8
XFILLER_56_721 VDD VSS sg13cmos5l_decap_8
XFILLER_56_743 VDD VSS sg13cmos5l_fill_2
XFILLER_44_927 VDD VSS sg13cmos5l_decap_8
XFILLER_46_69 VDD VSS sg13cmos5l_decap_8
XFILLER_56_787 VDD VSS sg13cmos5l_fill_1
XFILLER_71_746 VDD VSS sg13cmos5l_decap_8
XFILLER_51_492 VDD VSS sg13cmos5l_decap_8
Xfanout380 _5645_/A _4027_/A VDD VSS sg13cmos5l_buf_1
Xfanout391 fanout391/X fanout392/X VDD VSS sg13cmos5l_buf_1
XFILLER_74_573 VDD VSS sg13cmos5l_decap_4
XFILLER_62_702 VDD VSS sg13cmos5l_fill_1
XFILLER_62_735 VDD VSS sg13cmos5l_decap_8
XFILLER_50_919 VDD VSS sg13cmos5l_fill_2
XFILLER_61_267 VDD VSS sg13cmos5l_fill_1
Xinput22 input22/X bank_A_wdata[21] VDD VSS sg13cmos5l_buf_1
X_4580_ _4597_/A _4580_/A _4580_/B VDD VSS sg13cmos5l_xor2_1
Xinput11 input11/X bank_A_wdata[11] VDD VSS sg13cmos5l_buf_1
Xinput33 input33/X bank_A_wdata[31] VDD VSS sg13cmos5l_buf_1
Xinput55 input55/X bank_B_wdata[14] VDD VSS sg13cmos5l_buf_1
Xinput44 _6193_/B bank_B_addr[2] VDD VSS sg13cmos5l_buf_1
Xinput88 _7707_/D quant_cfg[16] VDD VSS sg13cmos5l_buf_1
Xinput77 input77/X bank_B_wdata[5] VDD VSS sg13cmos5l_buf_1
Xinput66 input66/X bank_B_wdata[24] VDD VSS sg13cmos5l_buf_1
Xinput99 _7718_/D quant_cfg[27] VDD VSS sg13cmos5l_buf_1
X_6250_ _6565_/C _6720_/A _6355_/A _6533_/C VDD VSS sg13cmos5l_nor3_2
X_6181_ _6182_/B _6181_/A _6181_/B VDD VSS sg13cmos5l_xnor2_1
X_5201_ _5202_/B _5269_/A _5756_/A2 _5257_/A _5756_/B2 VDD VSS sg13cmos5l_a22oi_1
X_5132_ _5133_/B _5684_/B1 _5258_/A _5622_/B1 _5259_/A VDD VSS sg13cmos5l_a22oi_1
XFILLER_69_378 VDD VSS sg13cmos5l_fill_2
XFILLER_57_507 VDD VSS sg13cmos5l_decap_8
XFILLER_78_890 VDD VSS sg13cmos5l_fill_2
X_5063_ _5063_/X _5063_/A VDD VSS sg13cmos5l_buf_1
X_4014_ _4100_/A _4014_/A _4014_/B VDD VSS sg13cmos5l_nand2_1
XFILLER_53_735 VDD VSS sg13cmos5l_fill_2
XFILLER_53_757 VDD VSS sg13cmos5l_decap_8
XFILLER_41_919 VDD VSS sg13cmos5l_decap_8
X_5965_ _5966_/B _6010_/B _6010_/A VDD VSS sg13cmos5l_xor2_1
X_7704_ _7704_/Q _7704_/CLK _7704_/D fanout383/X VDD VSS sg13cmos5l_dfrbpq_1
X_4916_ _4916_/Y _4916_/A _4865_/A VDD VSS sg13cmos5l_nor2b_1
X_5896_ _5906_/A _5982_/A _5896_/B VDD VSS sg13cmos5l_xnor2_1
X_7635_ _7636_/B _7635_/A _7635_/B VDD VSS sg13cmos5l_xor2_1
XFILLER_32_27 VDD VSS sg13cmos5l_fill_2
X_4847_ _4847_/Y _4847_/A _4847_/B VDD VSS sg13cmos5l_nand2_2
X_7566_ _7569_/C _7621_/B _7566_/B VDD VSS sg13cmos5l_nand2_1
X_4778_ _4780_/A _4712_/B _4778_/B VDD VSS sg13cmos5l_nand2b_1
XFILLER_113_8 VDD VSS sg13cmos5l_decap_8
X_6517_ _6518_/A _6918_/B _7008_/B _6517_/C _6548_/D VDD VSS sg13cmos5l_nor4_1
X_7497_ _7497_/Y _7498_/A _7574_/B _7498_/B VDD VSS sg13cmos5l_a21oi_1
X_6448_ _6457_/C _6541_/A _6448_/B VDD VSS sg13cmos5l_nand2_1
X_6379_ _6389_/A _6379_/A _6380_/A VDD VSS sg13cmos5l_nor2b_2
XFILLER_76_827 VDD VSS sg13cmos5l_fill_2
XFILLER_57_24 VDD VSS sg13cmos5l_decap_4
XFILLER_75_337 VDD VSS sg13cmos5l_decap_4
XFILLER_75_304 VDD VSS sg13cmos5l_fill_1
XFILLER_75_359 VDD VSS sg13cmos5l_decap_8
XFILLER_43_201 VDD VSS sg13cmos5l_decap_8
XFILLER_56_562 VDD VSS sg13cmos5l_decap_8
XFILLER_73_45 VDD VSS sg13cmos5l_decap_8
XFILLER_71_532 VDD VSS sg13cmos5l_fill_1
XFILLER_71_521 VDD VSS sg13cmos5l_decap_8
XFILLER_43_223 VDD VSS sg13cmos5l_decap_4
XFILLER_44_735 VDD VSS sg13cmos5l_fill_2
XFILLER_71_576 VDD VSS sg13cmos5l_fill_1
XFILLER_71_565 VDD VSS sg13cmos5l_fill_1
XFILLER_43_267 VDD VSS sg13cmos5l_fill_1
XFILLER_44_779 VDD VSS sg13cmos5l_fill_1
XFILLER_71_598 VDD VSS sg13cmos5l_decap_8
Xclkbuf_0_clk_i_regs clkbuf_0_clk_i_regs/X clkbuf_regs_0_clk_i/X VDD VSS sg13cmos5l_buf_8
XFILLER_79_621 VDD VSS sg13cmos5l_decap_8
XFILLER_67_849 VDD VSS sg13cmos5l_decap_8
XFILLER_74_381 VDD VSS sg13cmos5l_fill_2
XFILLER_62_510 VDD VSS sg13cmos5l_decap_8
X_5750_ _5789_/A _5704_/B _5704_/A _5749_/X VDD VSS sg13cmos5l_a21oi_1
X_4701_ _4702_/C _5063_/A VDD VSS sg13cmos5l_inv_1
X_5681_ _5775_/A _5629_/B _5629_/A _5680_/Y VDD VSS sg13cmos5l_a21oi_1
X_4632_ _4633_/B _5178_/B1 _4751_/A _5117_/B1 _4752_/A VDD VSS sg13cmos5l_a22oi_1
X_7420_ _7421_/A _7430_/A _7431_/A VDD VSS sg13cmos5l_nor2_1
X_7351_ _7360_/A _7404_/A _7167_/Y _7350_/Y VDD VSS sg13cmos5l_o21ai_1
X_4563_ _4563_/X _4563_/A VDD VSS sg13cmos5l_buf_1
X_7282_ _7556_/A _7352_/A _7306_/A VDD VSS sg13cmos5l_xnor2_1
X_6302_ _6465_/B _6979_/B _6355_/A _6533_/C VDD VSS sg13cmos5l_nor3_1
X_4494_ _4495_/B _4494_/A _4494_/B VDD VSS sg13cmos5l_xor2_1
X_6233_ _6244_/A _6233_/A VDD VSS sg13cmos5l_buf_8
X_6164_ _6173_/B _6143_/B _6143_/A _6163_/Y VDD VSS sg13cmos5l_a21o_1
XFILLER_69_186 VDD VSS sg13cmos5l_fill_1
X_6095_ _6096_/B _6095_/A _6095_/B VDD VSS sg13cmos5l_nand2_1
X_5115_ _5126_/A _5053_/B _5048_/A _5115_/S VDD VSS sg13cmos5l_mux2_1
X_5046_ _5046_/Y _5046_/A _4992_/A VDD VSS sg13cmos5l_nor2b_1
XFILLER_38_562 VDD VSS sg13cmos5l_decap_4
XFILLER_81_874 VDD VSS sg13cmos5l_fill_2
X_6997_ _6997_/Y _7044_/A _6997_/B VDD VSS sg13cmos5l_nor2_1
XFILLER_81_896 VDD VSS sg13cmos5l_fill_1
XFILLER_80_395 VDD VSS sg13cmos5l_decap_8
XFILLER_40_204 VDD VSS sg13cmos5l_decap_8
X_5948_ _5955_/A _5912_/B _5788_/A _5948_/S VDD VSS sg13cmos5l_mux2_1
Xrebuffer700 _7318_/A rebuffer730/X VDD VSS sg13cmos5l_buf_1
X_5879_ _5923_/A _5918_/A _5918_/B VDD VSS sg13cmos5l_xor2_1
X_7618_ _7619_/D _7618_/A _7618_/B _7618_/C _7618_/D VDD VSS sg13cmos5l_nor4_1
Xrebuffer722 rebuffer722/X rebuffer723/X VDD VSS sg13cmos5l_buf_1
Xrebuffer733 rebuffer733/X rebuffer734/X VDD VSS sg13cmos5l_buf_1
Xrebuffer711 rebuffer711/X rebuffer712/X VDD VSS sg13cmos5l_buf_1
X_7549_ _7561_/B _7618_/B VDD VSS sg13cmos5l_inv_1
Xrebuffer766 _7558_/B _7304_/A VDD VSS sg13cmos5l_buf_1
Xrebuffer744 rebuffer744/X rebuffer745/X VDD VSS sg13cmos5l_buf_1
Xrebuffer755 _7496_/B _7444_/A VDD VSS sg13cmos5l_buf_1
Xrebuffer777 _6826_/B _6394_/A VDD VSS sg13cmos5l_buf_1
XFILLER_104_4 VDD VSS sg13cmos5l_decap_8
XFILLER_76_602 VDD VSS sg13cmos5l_decap_4
XFILLER_68_78 VDD VSS sg13cmos5l_fill_2
XFILLER_68_67 VDD VSS sg13cmos5l_fill_2
XFILLER_48_304 VDD VSS sg13cmos5l_fill_1
XFILLER_49_827 VDD VSS sg13cmos5l_fill_2
XFILLER_84_22 VDD VSS sg13cmos5l_decap_8
XFILLER_76_657 VDD VSS sg13cmos5l_fill_1
XFILLER_75_134 VDD VSS sg13cmos5l_fill_1
XFILLER_72_841 VDD VSS sg13cmos5l_fill_2
XFILLER_44_521 VDD VSS sg13cmos5l_fill_2
XFILLER_72_863 VDD VSS sg13cmos5l_decap_8
XFILLER_71_340 VDD VSS sg13cmos5l_decap_8
XFILLER_55_808 VDD VSS sg13cmos5l_decap_8
XFILLER_55_819 VDD VSS sg13cmos5l_fill_2
XFILLER_35_532 VDD VSS sg13cmos5l_decap_8
X_6920_ _6921_/A _6917_/Y _7054_/A _6943_/A VDD VSS sg13cmos5l_mux2_1
XFILLER_63_841 VDD VSS sg13cmos5l_decap_4
XFILLER_35_543 VDD VSS sg13cmos5l_fill_1
X_6851_ _6947_/A _6851_/A _6851_/B VDD VSS sg13cmos5l_xor2_1
X_5802_ _5808_/A _5982_/A _5802_/B VDD VSS sg13cmos5l_xnor2_1
X_3994_ _5811_/B _5645_/A _3995_/B VDD VSS sg13cmos5l_nor2_1
X_6782_ _6783_/A _7483_/B _6982_/A _7274_/A VDD VSS sg13cmos5l_a21oi_1
XFILLER_50_557 VDD VSS sg13cmos5l_fill_2
X_5733_ _5736_/B _5733_/A _5733_/B VDD VSS sg13cmos5l_nand2_1
X_5664_ _5667_/A _5782_/A VDD VSS sg13cmos5l_inv_1
X_4615_ _4665_/A _5044_/A _4615_/B VDD VSS sg13cmos5l_nor2_1
X_5595_ _5597_/A _5529_/B _5595_/B VDD VSS sg13cmos5l_nand2b_1
X_7403_ _7408_/B _7413_/B VDD VSS sg13cmos5l_inv_1
X_7334_ _7335_/A _7327_/A _7077_/Y _7333_/Y VDD VSS sg13cmos5l_o21ai_1
X_4546_ _4548_/A _4547_/A _4547_/B _4547_/C VDD VSS sg13cmos5l_a21oi_1
X_7265_ _7265_/Y _7265_/A _7265_/B VDD VSS sg13cmos5l_nor2_1
X_4477_ _4478_/B _4479_/A _4479_/B VDD VSS sg13cmos5l_nand2_1
X_6216_ _6216_/Y _6185_/X _6189_/Y _6215_/Y VDD VSS sg13cmos5l_o21ai_1
X_7196_ _7196_/Y _7192_/Y _7218_/A _7195_/X VDD VSS sg13cmos5l_a21oi_1
X_6147_ _6149_/A _6147_/A _6166_/A VDD VSS sg13cmos5l_xor2_1
XFILLER_57_112 VDD VSS sg13cmos5l_fill_2
XFILLER_58_646 VDD VSS sg13cmos5l_decap_4
XFILLER_73_616 VDD VSS sg13cmos5l_fill_2
X_6078_ _7701_/D _6078_/A _6078_/B VDD VSS sg13cmos5l_xor2_1
XFILLER_73_649 VDD VSS sg13cmos5l_fill_1
XFILLER_72_104 VDD VSS sg13cmos5l_fill_2
X_5029_ _5042_/B _5029_/A _5029_/B VDD VSS sg13cmos5l_xor2_1
XFILLER_80_192 VDD VSS sg13cmos5l_decap_8
Xbank_A_sram.gen_ihp_256x32.u_sram_256x32_401 bank_A_sram.gen_ihp_256x32.u_sram_256x32_401/L_LO
+ VDD VSS sg13cmos5l_tielo
Xbank_A_sram.gen_ihp_256x32.u_sram_256x32_445 bank_A_sram.gen_ihp_256x32.u_sram_256x32_445/L_LO
+ VDD VSS sg13cmos5l_tielo
Xbank_A_sram.gen_ihp_256x32.u_sram_256x32_412 bank_A_sram.gen_ihp_256x32.u_sram_256x32_412/L_LO
+ VDD VSS sg13cmos5l_tielo
Xbank_A_sram.gen_ihp_256x32.u_sram_256x32_434 bank_A_sram.gen_ihp_256x32.u_sram_256x32_434/L_LO
+ VDD VSS sg13cmos5l_tielo
Xbank_A_sram.gen_ihp_256x32.u_sram_256x32_423 bank_A_sram.gen_ihp_256x32.u_sram_256x32_423/L_LO
+ VDD VSS sg13cmos5l_tielo
Xbank_A_sram.gen_ihp_256x32.u_sram_256x32_467 bank_A_sram.gen_ihp_256x32.u_sram_256x32_467/L_LO
+ VDD VSS sg13cmos5l_tielo
Xbank_A_sram.gen_ihp_256x32.u_sram_256x32_456 bank_A_sram.gen_ihp_256x32.u_sram_256x32_456/L_LO
+ VDD VSS sg13cmos5l_tielo
XFILLER_76_454 VDD VSS sg13cmos5l_fill_1
Xbank_B_sram.gen_ihp_256x32.u_sram_256x32_471 bank_B_sram.gen_ihp_256x32.u_sram_256x32_471/L_LO
+ VDD VSS sg13cmos5l_tielo
Xbank_B_sram.gen_ihp_256x32.u_sram_256x32_482 bank_B_sram.gen_ihp_256x32.u_sram_256x32_482/L_LO
+ VDD VSS sg13cmos5l_tielo
Xbank_B_sram.gen_ihp_256x32.u_sram_256x32_493 bank_B_sram.gen_ihp_256x32.u_sram_256x32_493/L_LO
+ VDD VSS sg13cmos5l_tielo
X_4400_ _4400_/Y _4400_/A _4400_/B VDD VSS sg13cmos5l_nand2_1
X_5380_ _5381_/B _5684_/B1 _5568_/A _5622_/B1 _5569_/A VDD VSS sg13cmos5l_a22oi_1
X_4331_ _4382_/B _4528_/A _4331_/B VDD VSS sg13cmos5l_xnor2_1
X_4262_ _4262_/X _4262_/A VDD VSS sg13cmos5l_buf_1
X_7050_ _7050_/Y _7047_/Y _7080_/A _7126_/B VDD VSS sg13cmos5l_o21ai_1
Xfanout209 _7164_/A _7160_/A VDD VSS sg13cmos5l_buf_1
X_6001_ _6004_/A _6001_/A VDD VSS sg13cmos5l_inv_1
XFILLER_39_134 VDD VSS sg13cmos5l_decap_8
X_4193_ _4432_/A _4257_/B VDD VSS sg13cmos5l_buf_1
XFILLER_67_498 VDD VSS sg13cmos5l_decap_4
XFILLER_36_830 VDD VSS sg13cmos5l_decap_8
X_6903_ _6903_/Y _6903_/A VDD VSS sg13cmos5l_inv_1
XFILLER_50_310 VDD VSS sg13cmos5l_decap_4
XFILLER_50_332 VDD VSS sg13cmos5l_fill_1
X_6834_ _6834_/Y _6834_/A _6834_/B VDD VSS sg13cmos5l_nor2_1
X_3977_ _3993_/B _3977_/A _3977_/B _3977_/C VDD VSS sg13cmos5l_nor3_1
X_6765_ _6766_/A _6765_/A _6765_/B VDD VSS sg13cmos5l_xnor2_1
XFILLER_50_354 VDD VSS sg13cmos5l_fill_1
XFILLER_51_877 VDD VSS sg13cmos5l_decap_4
X_5716_ _5716_/Y _5716_/A _5647_/A VDD VSS sg13cmos5l_nor2b_1
X_6696_ _6696_/Y _6696_/A VDD VSS sg13cmos5l_inv_1
X_5647_ _5694_/B _5647_/A _5716_/A VDD VSS sg13cmos5l_xor2_1
X_5578_ _5592_/A _5578_/A _5578_/B VDD VSS sg13cmos5l_xor2_1
X_7317_ _7551_/A _7317_/A _7529_/A VDD VSS sg13cmos5l_nand2_2
X_4529_ _4529_/X _4529_/A VDD VSS sg13cmos5l_buf_1
XFILLER_6_8 VDD VSS sg13cmos5l_decap_8
X_7248_ _7248_/X _7248_/A VDD VSS sg13cmos5l_buf_1
Xrebuffer1240 rebuffer1240/X rebuffer1241/X VDD VSS sg13cmos5l_buf_1
XFILLER_59_933 VDD VSS sg13cmos5l_fill_1
X_7179_ _7179_/X _7195_/B VDD VSS sg13cmos5l_buf_1
XFILLER_46_616 VDD VSS sg13cmos5l_decap_8
XFILLER_58_465 VDD VSS sg13cmos5l_decap_8
XFILLER_73_413 VDD VSS sg13cmos5l_fill_2
XFILLER_45_159 VDD VSS sg13cmos5l_fill_2
XFILLER_42_800 VDD VSS sg13cmos5l_fill_2
XFILLER_41_376 VDD VSS sg13cmos5l_fill_2
XFILLER_41_398 VDD VSS sg13cmos5l_decap_4
XFILLER_39_8 VDD VSS sg13cmos5l_decap_8
XFILLER_76_251 VDD VSS sg13cmos5l_decap_8
XFILLER_65_903 VDD VSS sg13cmos5l_fill_2
Xinput9 input9/X bank_A_wdata[0] VDD VSS sg13cmos5l_buf_1
XFILLER_36_137 VDD VSS sg13cmos5l_decap_8
XFILLER_80_928 VDD VSS sg13cmos5l_decap_4
X_4880_ _4881_/B _4924_/A _4924_/B VDD VSS sg13cmos5l_xor2_1
X_6550_ _6552_/A _6560_/A _6560_/B VDD VSS sg13cmos5l_xnor2_1
X_5501_ _5501_/Y _5501_/A _5467_/B VDD VSS sg13cmos5l_nor2b_1
X_6481_ _6482_/B _6479_/B _7680_/Q VDD VSS sg13cmos5l_nand2b_1
XFILLER_10_19 VDD VSS sg13cmos5l_decap_8
X_5432_ _5433_/B _5793_/A _5432_/B VDD VSS sg13cmos5l_xnor2_1
X_5363_ _5365_/A _5363_/A _5363_/B VDD VSS sg13cmos5l_nand2_1
XFILLER_58_0 VDD VSS sg13cmos5l_fill_1
X_4314_ _4314_/X _4314_/A VDD VSS sg13cmos5l_buf_1
X_7102_ _7103_/A _7134_/B _6846_/Y _7101_/Y VDD VSS sg13cmos5l_o21ai_1
X_5294_ _5297_/A _5294_/A _5301_/A VDD VSS sg13cmos5l_xnor2_1
X_4245_ _4294_/B _4245_/A _4245_/B VDD VSS sg13cmos5l_nand2_2
XFILLER_68_730 VDD VSS sg13cmos5l_decap_8
XFILLER_19_17 VDD VSS sg13cmos5l_decap_8
XFILLER_19_28 VDD VSS sg13cmos5l_fill_1
X_7033_ _7164_/B _7018_/B _6840_/Y _7032_/Y VDD VSS sg13cmos5l_o21ai_1
X_4176_ _4212_/B _4223_/A _4176_/B VDD VSS sg13cmos5l_xnor2_1
XFILLER_67_295 VDD VSS sg13cmos5l_decap_4
XFILLER_82_265 VDD VSS sg13cmos5l_decap_4
XFILLER_36_671 VDD VSS sg13cmos5l_fill_1
XFILLER_35_38 VDD VSS sg13cmos5l_decap_8
XFILLER_55_479 VDD VSS sg13cmos5l_decap_8
XFILLER_82_298 VDD VSS sg13cmos5l_decap_4
XFILLER_70_449 VDD VSS sg13cmos5l_fill_1
X_6817_ _7014_/B _6962_/A _6813_/S _6816_/X VDD VSS sg13cmos5l_a21oi_1
XFILLER_50_173 VDD VSS sg13cmos5l_fill_2
X_6748_ _6748_/Y _6997_/B _6996_/A VDD VSS sg13cmos5l_nand2_1
X_6679_ _6681_/B _6688_/A _6679_/B VDD VSS sg13cmos5l_nand2_1
XFILLER_59_730 VDD VSS sg13cmos5l_decap_8
XFILLER_59_752 VDD VSS sg13cmos5l_fill_2
XFILLER_58_273 VDD VSS sg13cmos5l_decap_8
XFILLER_92_11 VDD VSS sg13cmos5l_decap_8
XFILLER_46_446 VDD VSS sg13cmos5l_fill_2
XFILLER_42_696 VDD VSS sg13cmos5l_decap_8
X_4030_ _4050_/B _4528_/A _4030_/B VDD VSS sg13cmos5l_xnor2_1
XFILLER_37_479 VDD VSS sg13cmos5l_decap_8
X_5981_ _5982_/B _6114_/B _5568_/X _6082_/A1 _5569_/X VDD VSS sg13cmos5l_a22oi_1
XFILLER_65_788 VDD VSS sg13cmos5l_decap_8
X_7720_ _7720_/Q clkload8/A _7720_/D fanout390/X VDD VSS sg13cmos5l_dfrbpq_1
X_4932_ _4932_/X _4932_/A VDD VSS sg13cmos5l_buf_1
X_7651_ _7652_/B _7651_/A _7651_/B VDD VSS sg13cmos5l_nand2_1
XANTENNA_14 input11/X VDD VSS sg13cmos5l_antennanp
X_6602_ _6605_/B _6621_/A _6602_/B VDD VSS sg13cmos5l_nor2_1
X_4863_ _4863_/X _4863_/A _4863_/B VDD VSS sg13cmos5l_and2_1
XANTENNA_25 _7710_/D VDD VSS sg13cmos5l_antennanp
X_4794_ _4794_/Y _4794_/A _4782_/B VDD VSS sg13cmos5l_nor2b_1
X_7582_ _7624_/B _7582_/A _7582_/B VDD VSS sg13cmos5l_xnor2_1
X_6533_ _6542_/A _6979_/B _7008_/B _6533_/C _6548_/D VDD VSS sg13cmos5l_nor4_1
X_6464_ _6471_/A _6464_/A _6464_/B VDD VSS sg13cmos5l_nand2_2
Xoutput110 act_out[2] _6218_/Y VDD VSS sg13cmos5l_buf_1
X_5415_ _5481_/A _5415_/A _5415_/B VDD VSS sg13cmos5l_xnor2_1
Xoutput132 bank_A_rdata[24] _5074_/A VDD VSS sg13cmos5l_buf_1
Xoutput121 bank_A_rdata[14] _4444_/A VDD VSS sg13cmos5l_buf_1
Xoutput143 bank_A_rdata[5] _4021_/A VDD VSS sg13cmos5l_buf_1
X_6395_ _6396_/B _6393_/B _7671_/Q VDD VSS sg13cmos5l_nand2b_1
Xoutput165 bank_B_rdata[25] output165/A VDD VSS sg13cmos5l_buf_1
Xoutput176 bank_B_rdata[6] _6225_/B VDD VSS sg13cmos5l_buf_1
Xoutput154 bank_B_rdata[15] output154/A VDD VSS sg13cmos5l_buf_1
X_5346_ _5346_/Y _5346_/A VDD VSS sg13cmos5l_inv_1
X_5277_ _5328_/A _5142_/X _5572_/A _5276_/Y VDD VSS sg13cmos5l_a21o_1
X_4228_ _4229_/B _4228_/A _4253_/B VDD VSS sg13cmos5l_xor2_1
X_7016_ _7016_/Y _7030_/B _7016_/B VDD VSS sg13cmos5l_nor2_1
XFILLER_68_560 VDD VSS sg13cmos5l_decap_4
X_4159_ _4159_/Y _5978_/B _4266_/A VDD VSS sg13cmos5l_nand2_1
XFILLER_44_906 VDD VSS sg13cmos5l_decap_8
XFILLER_46_26 VDD VSS sg13cmos5l_decap_8
XFILLER_55_221 VDD VSS sg13cmos5l_fill_1
XFILLER_55_276 VDD VSS sg13cmos5l_decap_8
XFILLER_36_490 VDD VSS sg13cmos5l_decap_8
XFILLER_70_257 VDD VSS sg13cmos5l_decap_8
XFILLER_70_246 VDD VSS sg13cmos5l_decap_4
XFILLER_51_471 VDD VSS sg13cmos5l_decap_8
XFILLER_62_58 VDD VSS sg13cmos5l_decap_8
XFILLER_87_22 VDD VSS sg13cmos5l_decap_8
XFILLER_78_379 VDD VSS sg13cmos5l_fill_1
XFILLER_78_346 VDD VSS sg13cmos5l_decap_8
Xfanout381 _4128_/A _4172_/A VDD VSS sg13cmos5l_buf_1
Xfanout370 _4525_/A _4276_/A VDD VSS sg13cmos5l_buf_1
Xfanout392 fanout392/X input107/X VDD VSS sg13cmos5l_buf_1
XFILLER_46_221 VDD VSS sg13cmos5l_fill_1
XFILLER_46_232 VDD VSS sg13cmos5l_fill_2
XFILLER_35_928 VDD VSS sg13cmos5l_decap_4
XFILLER_46_265 VDD VSS sg13cmos5l_decap_8
XFILLER_36_81 VDD VSS sg13cmos5l_decap_8
XFILLER_70_780 VDD VSS sg13cmos5l_decap_4
Xinput12 input12/X bank_A_wdata[12] VDD VSS sg13cmos5l_buf_1
Xinput23 input23/X bank_A_wdata[22] VDD VSS sg13cmos5l_buf_1
Xinput45 _6196_/B bank_B_addr[3] VDD VSS sg13cmos5l_buf_1
Xinput34 input34/X bank_A_wdata[3] VDD VSS sg13cmos5l_buf_1
Xinput89 _7708_/D quant_cfg[17] VDD VSS sg13cmos5l_buf_1
Xinput56 input56/X bank_B_wdata[15] VDD VSS sg13cmos5l_buf_1
Xinput78 input78/X bank_B_wdata[6] VDD VSS sg13cmos5l_buf_1
Xinput67 input67/X bank_B_wdata[25] VDD VSS sg13cmos5l_buf_1
X_5200_ _5200_/X _5200_/A VDD VSS sg13cmos5l_buf_1
X_6180_ _7706_/D _6180_/A _6180_/B VDD VSS sg13cmos5l_xnor2_1
XFILLER_69_324 VDD VSS sg13cmos5l_decap_4
XFILLER_69_313 VDD VSS sg13cmos5l_decap_4
X_5131_ _5131_/X _5131_/A VDD VSS sg13cmos5l_buf_1
XFILLER_69_368 VDD VSS sg13cmos5l_fill_2
XFILLER_69_357 VDD VSS sg13cmos5l_decap_4
X_5062_ _5069_/A _5630_/A _5062_/B VDD VSS sg13cmos5l_xnor2_1
X_4013_ _7663_/D _4013_/A _4014_/A VDD VSS sg13cmos5l_xnor2_1
XFILLER_38_755 VDD VSS sg13cmos5l_decap_4
XFILLER_37_221 VDD VSS sg13cmos5l_decap_4
XFILLER_38_788 VDD VSS sg13cmos5l_decap_4
XFILLER_65_563 VDD VSS sg13cmos5l_decap_4
XFILLER_80_511 VDD VSS sg13cmos5l_decap_8
XFILLER_37_287 VDD VSS sg13cmos5l_decap_8
XFILLER_16_18 VDD VSS sg13cmos5l_decap_8
XFILLER_65_596 VDD VSS sg13cmos5l_fill_2
X_7703_ _7703_/Q clkload2/A _7703_/D fanout393/X VDD VSS sg13cmos5l_dfrbpq_1
XFILLER_40_408 VDD VSS sg13cmos5l_fill_1
X_5964_ _6010_/A _5964_/A _6005_/A VDD VSS sg13cmos5l_xnor2_1
XFILLER_52_257 VDD VSS sg13cmos5l_fill_1
XFILLER_53_769 VDD VSS sg13cmos5l_fill_1
X_4915_ _4978_/B _5044_/A _4915_/B VDD VSS sg13cmos5l_nor2_1
X_5895_ _5896_/B _6082_/B1 _5941_/A2 _6058_/B1 _5941_/B2 VDD VSS sg13cmos5l_a22oi_1
X_7634_ _7721_/D _7658_/B _7634_/B VDD VSS sg13cmos5l_nand2_2
X_4846_ _4846_/Y _4846_/A _4786_/A VDD VSS sg13cmos5l_nor2b_1
X_7565_ _7566_/B _7619_/A _7619_/B _7565_/C _7565_/D VDD VSS sg13cmos5l_nor4_2
X_6516_ _7038_/B _6516_/A VDD VSS sg13cmos5l_buf_4
X_4777_ _4781_/A _4837_/B _4777_/B VDD VSS sg13cmos5l_xnor2_1
X_7496_ _7626_/B _7496_/A _7496_/B VDD VSS sg13cmos5l_xnor2_1
X_6447_ _6453_/A _6447_/A _6447_/B VDD VSS sg13cmos5l_nand2_2
Xclkbuf_4_10_0_clk_i_regs _7675_/CLK clkbuf_0_clk_i_regs/X VDD VSS sg13cmos5l_buf_8
X_6378_ _6380_/A _6621_/A _6663_/B VDD VSS sg13cmos5l_nand2_1
X_5329_ _5378_/A _5281_/B _5281_/A _5328_/Y VDD VSS sg13cmos5l_a21oi_1
XFILLER_75_316 VDD VSS sg13cmos5l_fill_1
XFILLER_57_69 VDD VSS sg13cmos5l_fill_1
XFILLER_57_58 VDD VSS sg13cmos5l_decap_8
XFILLER_44_758 VDD VSS sg13cmos5l_fill_1
XFILLER_43_257 VDD VSS sg13cmos5l_fill_1
XFILLER_40_931 VDD VSS sg13cmos5l_fill_2
XFILLER_78_110 VDD VSS sg13cmos5l_fill_1
XFILLER_79_677 VDD VSS sg13cmos5l_fill_1
XFILLER_79_655 VDD VSS sg13cmos5l_fill_2
XFILLER_21_8 VDD VSS sg13cmos5l_decap_8
XFILLER_82_809 VDD VSS sg13cmos5l_fill_1
XFILLER_35_703 VDD VSS sg13cmos5l_decap_4
XFILLER_47_80 VDD VSS sg13cmos5l_decap_4
XFILLER_50_706 VDD VSS sg13cmos5l_fill_2
XFILLER_43_780 VDD VSS sg13cmos5l_decap_8
X_4700_ _4703_/A _3930_/X _5063_/A _4944_/A VDD VSS sg13cmos5l_a21oi_1
X_5680_ _5680_/Y _5680_/A _5628_/A VDD VSS sg13cmos5l_nor2b_1
X_4631_ _4631_/X _4631_/A VDD VSS sg13cmos5l_buf_1
X_7350_ _7350_/Y _7157_/Y _7394_/A2 _7377_/B VDD VSS sg13cmos5l_a21oi_1
X_4562_ _4618_/S _3964_/C _4737_/A _3965_/B _5116_/A VDD VSS sg13cmos5l_a22oi_1
X_7281_ _7306_/A _7343_/A _7281_/B VDD VSS sg13cmos5l_nand2b_1
X_6301_ _6309_/A _6301_/A _6301_/B VDD VSS sg13cmos5l_nand2_2
X_4493_ _4737_/A _4495_/A VDD VSS sg13cmos5l_inv_1
X_6232_ _6233_/A _6915_/A _6768_/A VDD VSS sg13cmos5l_nor2_2
X_6163_ _6163_/Y _6163_/A _6141_/B VDD VSS sg13cmos5l_nor2b_1
XFILLER_58_806 VDD VSS sg13cmos5l_fill_2
XFILLER_58_817 VDD VSS sg13cmos5l_decap_8
X_6094_ _6095_/B _6094_/A _6094_/B VDD VSS sg13cmos5l_nand2_1
X_5114_ _5222_/A _5057_/B _5057_/A _5113_/Y VDD VSS sg13cmos5l_a21oi_1
X_5045_ _5109_/B _5781_/A _5045_/B VDD VSS sg13cmos5l_nor2_1
XFILLER_53_511 VDD VSS sg13cmos5l_fill_2
X_6996_ _7018_/B _6996_/A VDD VSS sg13cmos5l_buf_1
XFILLER_80_374 VDD VSS sg13cmos5l_decap_8
XFILLER_41_728 VDD VSS sg13cmos5l_fill_2
X_5947_ _5956_/A _5947_/A _5947_/B VDD VSS sg13cmos5l_xor2_1
X_7617_ _7618_/C _7560_/B _7617_/B _7617_/C VDD VSS sg13cmos5l_nand3b_1
X_5878_ _5918_/B _5878_/A _5878_/B VDD VSS sg13cmos5l_xnor2_1
X_4829_ _4830_/B _5063_/A _5081_/A _5000_/A _5082_/A VDD VSS sg13cmos5l_a22oi_1
Xrebuffer723 rebuffer723/X rebuffer724/X VDD VSS sg13cmos5l_buf_1
Xrebuffer712 rebuffer712/X rebuffer713/X VDD VSS sg13cmos5l_buf_1
Xrebuffer701 rebuffer701/X rebuffer702/X VDD VSS sg13cmos5l_buf_1
X_7548_ _7618_/B _7548_/A _7548_/B VDD VSS sg13cmos5l_xnor2_1
Xrebuffer767 rebuffer767/X _7361_/A VDD VSS sg13cmos5l_buf_1
Xrebuffer745 rebuffer745/X rebuffer746/X VDD VSS sg13cmos5l_buf_1
Xrebuffer734 rebuffer734/X rebuffer735/X VDD VSS sg13cmos5l_buf_1
Xrebuffer756 _7498_/A _7432_/A VDD VSS sg13cmos5l_buf_1
X_7479_ _7480_/A _7605_/A _7603_/B _7605_/B _7605_/C VDD VSS sg13cmos5l_nand4_1
Xrebuffer778 _7465_/A _7598_/A VDD VSS sg13cmos5l_buf_1
XFILLER_68_46 VDD VSS sg13cmos5l_decap_8
XFILLER_75_124 VDD VSS sg13cmos5l_fill_2
XFILLER_48_349 VDD VSS sg13cmos5l_fill_1
XFILLER_75_146 VDD VSS sg13cmos5l_decap_8
XFILLER_63_319 VDD VSS sg13cmos5l_fill_1
XFILLER_72_820 VDD VSS sg13cmos5l_decap_8
XFILLER_71_396 VDD VSS sg13cmos5l_decap_8
XFILLER_40_783 VDD VSS sg13cmos5l_decap_8
XFILLER_12_4 VDD VSS sg13cmos5l_decap_4
XFILLER_48_850 VDD VSS sg13cmos5l_fill_1
XFILLER_47_382 VDD VSS sg13cmos5l_decap_8
XFILLER_48_883 VDD VSS sg13cmos5l_decap_4
XFILLER_81_149 VDD VSS sg13cmos5l_decap_8
XFILLER_35_566 VDD VSS sg13cmos5l_fill_1
X_6850_ _7034_/A _6945_/A _6731_/X _6849_/X VDD VSS sg13cmos5l_a21oi_1
X_5801_ _5802_/B _5572_/X _5941_/A2 _5505_/X _5941_/B2 VDD VSS sg13cmos5l_a22oi_1
X_6781_ _7483_/B _6899_/B _6899_/A VDD VSS sg13cmos5l_nand2_2
XFILLER_35_599 VDD VSS sg13cmos5l_decap_4
XFILLER_50_514 VDD VSS sg13cmos5l_fill_2
X_3993_ _4037_/A _3993_/A _3993_/B VDD VSS sg13cmos5l_nand2_1
X_5732_ _5735_/A _5736_/C _5786_/B VDD VSS sg13cmos5l_nand2_1
X_5663_ _5782_/A _5665_/B _5665_/A VDD VSS sg13cmos5l_nor2_1
X_4614_ _4671_/A _4614_/A _4614_/B VDD VSS sg13cmos5l_nand2_1
X_5594_ _5598_/A _5594_/A _5655_/A VDD VSS sg13cmos5l_xnor2_1
X_7402_ _7413_/B _7503_/A _7578_/A VDD VSS sg13cmos5l_nand2_1
X_7333_ _7333_/Y _7425_/A2 _7394_/A2 _7343_/A VDD VSS sg13cmos5l_a21oi_1
X_4545_ _4547_/C _4545_/A _4611_/A VDD VSS sg13cmos5l_xnor2_1
X_7264_ _7265_/B _7276_/S _7264_/B VDD VSS sg13cmos5l_nor2_1
X_4476_ _4479_/B _4410_/A _4476_/B VDD VSS sg13cmos5l_nand2b_1
X_6215_ _6215_/Y _6219_/A _6215_/B VDD VSS sg13cmos5l_nand2_1
X_7195_ _7195_/X _7277_/A _7195_/B VDD VSS sg13cmos5l_and2_1
X_6146_ _6166_/A _6122_/B _6144_/Y _6145_/Y VDD VSS sg13cmos5l_a21oi_1
X_6077_ _6078_/B _6077_/A _6077_/B VDD VSS sg13cmos5l_nand2_2
XFILLER_73_628 VDD VSS sg13cmos5l_fill_2
XFILLER_66_680 VDD VSS sg13cmos5l_fill_2
XFILLER_39_894 VDD VSS sg13cmos5l_decap_8
XFILLER_38_371 VDD VSS sg13cmos5l_fill_2
X_5028_ _5029_/B _5096_/B _5096_/A VDD VSS sg13cmos5l_xor2_1
XFILLER_53_363 VDD VSS sg13cmos5l_decap_8
XFILLER_54_59 VDD VSS sg13cmos5l_fill_2
XFILLER_80_171 VDD VSS sg13cmos5l_decap_8
XFILLER_53_385 VDD VSS sg13cmos5l_decap_8
X_6979_ _6979_/Y _6979_/A _6979_/B _6979_/C _6979_/D VDD VSS sg13cmos5l_nand4_1
XFILLER_70_25 VDD VSS sg13cmos5l_decap_4
XFILLER_70_58 VDD VSS sg13cmos5l_decap_8
Xbank_A_sram.gen_ihp_256x32.u_sram_256x32_402 bank_A_sram.gen_ihp_256x32.u_sram_256x32_402/L_LO
+ VDD VSS sg13cmos5l_tielo
XFILLER_79_89 VDD VSS sg13cmos5l_fill_1
XFILLER_95_22 VDD VSS sg13cmos5l_decap_8
Xbank_A_sram.gen_ihp_256x32.u_sram_256x32_435 bank_A_sram.gen_ihp_256x32.u_sram_256x32_435/L_LO
+ VDD VSS sg13cmos5l_tielo
Xbank_A_sram.gen_ihp_256x32.u_sram_256x32_413 bank_A_sram.gen_ihp_256x32.u_sram_256x32_413/L_LO
+ VDD VSS sg13cmos5l_tielo
Xbank_A_sram.gen_ihp_256x32.u_sram_256x32_424 bank_A_sram.gen_ihp_256x32.u_sram_256x32_424/L_LO
+ VDD VSS sg13cmos5l_tielo
Xbank_A_sram.gen_ihp_256x32.u_sram_256x32_446 bank_A_sram.gen_ihp_256x32.u_sram_256x32_446/L_LO
+ VDD VSS sg13cmos5l_tielo
Xbank_A_sram.gen_ihp_256x32.u_sram_256x32_468 bank_A_sram.gen_ihp_256x32.u_sram_256x32_468/L_LO
+ VDD VSS sg13cmos5l_tielo
Xbank_A_sram.gen_ihp_256x32.u_sram_256x32_457 bank_A_sram.gen_ihp_256x32.u_sram_256x32_457/L_LO
+ VDD VSS sg13cmos5l_tielo
XFILLER_76_433 VDD VSS sg13cmos5l_fill_1
XFILLER_49_669 VDD VSS sg13cmos5l_decap_8
XFILLER_64_617 VDD VSS sg13cmos5l_decap_4
XFILLER_36_319 VDD VSS sg13cmos5l_decap_8
XFILLER_44_352 VDD VSS sg13cmos5l_decap_4
XFILLER_45_897 VDD VSS sg13cmos5l_fill_1
XFILLER_60_801 VDD VSS sg13cmos5l_fill_2
Xbank_B_sram.gen_ihp_256x32.u_sram_256x32_483 bank_B_sram.gen_ihp_256x32.u_sram_256x32_483/L_LO
+ VDD VSS sg13cmos5l_tielo
Xbank_B_sram.gen_ihp_256x32.u_sram_256x32_494 bank_B_sram.gen_ihp_256x32.u_sram_256x32_494/L_LO
+ VDD VSS sg13cmos5l_tielo
Xbank_B_sram.gen_ihp_256x32.u_sram_256x32_472 bank_B_sram.gen_ihp_256x32.u_sram_256x32_472/L_LO
+ VDD VSS sg13cmos5l_tielo
XFILLER_44_92 VDD VSS sg13cmos5l_fill_1
X_4330_ _4331_/B _4574_/A _4529_/A _4511_/A _4530_/A VDD VSS sg13cmos5l_a22oi_1
X_4261_ _4268_/A _4508_/A _4261_/B VDD VSS sg13cmos5l_xnor2_1
X_6000_ _6001_/A _5960_/A _5998_/Y _5999_/Y VDD VSS sg13cmos5l_o21ai_1
XFILLER_79_282 VDD VSS sg13cmos5l_decap_8
X_4192_ _4233_/B _4192_/A VDD VSS sg13cmos5l_inv_1
XFILLER_67_411 VDD VSS sg13cmos5l_fill_1
XFILLER_39_113 VDD VSS sg13cmos5l_decap_8
XFILLER_82_436 VDD VSS sg13cmos5l_decap_8
X_6902_ _6903_/A _6724_/A _6910_/S _6901_/Y VDD VSS sg13cmos5l_a21oi_1
XFILLER_54_149 VDD VSS sg13cmos5l_fill_1
XFILLER_36_886 VDD VSS sg13cmos5l_decap_8
XFILLER_35_363 VDD VSS sg13cmos5l_fill_1
X_6833_ _6834_/B _7008_/B _6833_/B VDD VSS sg13cmos5l_nor2_1
X_3976_ _3977_/C _4327_/B _4387_/A _3976_/C VDD VSS sg13cmos5l_nor3_1
X_6764_ _6764_/Y _6764_/A _6764_/B VDD VSS sg13cmos5l_xnor2_1
X_5715_ _5718_/A _5758_/A _5753_/B VDD VSS sg13cmos5l_xnor2_1
X_6695_ _6779_/A _6780_/A _6780_/B VDD VSS sg13cmos5l_nand2_2
X_5646_ _5716_/A _5710_/B _5646_/B VDD VSS sg13cmos5l_xnor2_1
X_5577_ _5578_/B _5626_/A _5626_/B VDD VSS sg13cmos5l_xor2_1
X_7316_ _7529_/A _7352_/A _7324_/A VDD VSS sg13cmos5l_xnor2_1
X_4528_ _4771_/A _4528_/A VDD VSS sg13cmos5l_buf_1
X_7247_ _7247_/Y _7057_/B _7246_/A _7246_/Y VDD VSS sg13cmos5l_a21oi_1
X_4459_ _4460_/B _4539_/B _4539_/A VDD VSS sg13cmos5l_xor2_1
Xrebuffer1230 _4065_/B _4064_/Y VDD VSS sg13cmos5l_buf_1
XFILLER_77_219 VDD VSS sg13cmos5l_decap_8
Xrebuffer1241 rebuffer1241/X rebuffer1242/X VDD VSS sg13cmos5l_buf_1
X_7178_ _7178_/X _7055_/X _7047_/Y _7191_/B VDD VSS sg13cmos5l_mux2_1
XFILLER_58_422 VDD VSS sg13cmos5l_decap_8
XFILLER_74_926 VDD VSS sg13cmos5l_decap_8
X_6129_ _6129_/Y _6129_/A _6129_/B VDD VSS sg13cmos5l_nand2_1
XFILLER_45_138 VDD VSS sg13cmos5l_decap_4
XFILLER_54_683 VDD VSS sg13cmos5l_decap_8
XFILLER_60_108 VDD VSS sg13cmos5l_fill_2
XFILLER_60_119 VDD VSS sg13cmos5l_decap_8
XFILLER_81_491 VDD VSS sg13cmos5l_decap_8
XFILLER_81_35 VDD VSS sg13cmos5l_fill_1
XFILLER_81_24 VDD VSS sg13cmos5l_decap_8
XFILLER_53_171 VDD VSS sg13cmos5l_decap_8
XFILLER_41_355 VDD VSS sg13cmos5l_fill_1
XFILLER_81_79 VDD VSS sg13cmos5l_decap_8
XFILLER_68_208 VDD VSS sg13cmos5l_fill_1
XFILLER_39_92 VDD VSS sg13cmos5l_decap_8
XFILLER_36_116 VDD VSS sg13cmos5l_decap_8
XFILLER_52_609 VDD VSS sg13cmos5l_decap_4
XFILLER_64_469 VDD VSS sg13cmos5l_fill_2
XFILLER_45_672 VDD VSS sg13cmos5l_fill_2
XFILLER_45_661 VDD VSS sg13cmos5l_decap_8
XFILLER_60_620 VDD VSS sg13cmos5l_fill_1
XFILLER_60_675 VDD VSS sg13cmos5l_fill_1
XFILLER_60_664 VDD VSS sg13cmos5l_decap_8
X_5500_ _5595_/B _5500_/A _5500_/B VDD VSS sg13cmos5l_xor2_1
X_6480_ _6482_/A _6841_/B _6841_/A VDD VSS sg13cmos5l_nand2_2
X_5431_ _5432_/B _5063_/X _5118_/X _5557_/B1 _5119_/X VDD VSS sg13cmos5l_a22oi_1
X_5362_ _7687_/D _5362_/A _5362_/B VDD VSS sg13cmos5l_xnor2_1
Xclkbuf_4_15_0_clk_i_regs clkload9/A clkbuf_0_clk_i_regs/X VDD VSS sg13cmos5l_buf_8
X_4313_ _4313_/X _4313_/A VDD VSS sg13cmos5l_buf_1
X_7101_ _7101_/Y _7101_/A _7108_/S VDD VSS sg13cmos5l_nand2_1
X_5293_ _5301_/A _5225_/B _5225_/A _5292_/X VDD VSS sg13cmos5l_a21oi_1
X_7032_ _7032_/Y _7032_/A _7032_/B VDD VSS sg13cmos5l_nand2_1
X_4244_ _4245_/A _4242_/B _4244_/B VDD VSS sg13cmos5l_nand2b_1
X_4175_ _4176_/B _4375_/A _3950_/A _4310_/A _3981_/X VDD VSS sg13cmos5l_a22oi_1
XFILLER_56_926 VDD VSS sg13cmos5l_decap_8
XFILLER_82_222 VDD VSS sg13cmos5l_fill_1
XFILLER_55_447 VDD VSS sg13cmos5l_fill_1
XFILLER_82_255 VDD VSS sg13cmos5l_fill_2
XFILLER_42_108 VDD VSS sg13cmos5l_decap_8
XFILLER_42_119 VDD VSS sg13cmos5l_fill_1
XFILLER_36_683 VDD VSS sg13cmos5l_fill_1
XFILLER_51_664 VDD VSS sg13cmos5l_decap_4
X_6816_ _6816_/X _6816_/A _6927_/B VDD VSS sg13cmos5l_and2_1
XFILLER_51_697 VDD VSS sg13cmos5l_fill_1
X_6747_ _6747_/X _6943_/A VDD VSS sg13cmos5l_buf_1
X_3959_ _3972_/B _3963_/A VDD VSS sg13cmos5l_inv_1
XFILLER_50_196 VDD VSS sg13cmos5l_fill_2
X_6678_ _6686_/A _6678_/A _6678_/B VDD VSS sg13cmos5l_nand2_2
X_5629_ _5653_/A _5629_/A _5629_/B VDD VSS sg13cmos5l_xor2_1
XFILLER_78_528 VDD VSS sg13cmos5l_fill_1
XFILLER_59_742 VDD VSS sg13cmos5l_decap_4
XFILLER_59_797 VDD VSS sg13cmos5l_decap_8
XFILLER_73_266 VDD VSS sg13cmos5l_decap_4
XFILLER_73_299 VDD VSS sg13cmos5l_decap_8
XFILLER_54_491 VDD VSS sg13cmos5l_fill_2
XFILLER_41_152 VDD VSS sg13cmos5l_decap_4
XFILLER_77_572 VDD VSS sg13cmos5l_decap_8
XFILLER_65_756 VDD VSS sg13cmos5l_decap_8
XFILLER_65_767 VDD VSS sg13cmos5l_fill_2
XFILLER_52_417 VDD VSS sg13cmos5l_fill_2
XFILLER_52_406 VDD VSS sg13cmos5l_decap_8
X_5980_ _6057_/A _6025_/B VDD VSS sg13cmos5l_inv_1
XFILLER_52_439 VDD VSS sg13cmos5l_decap_8
X_4931_ _4938_/A _5060_/A _4931_/B VDD VSS sg13cmos5l_xnor2_1
X_7650_ _7652_/A _7650_/A _7650_/B VDD VSS sg13cmos5l_nand2_1
X_4862_ _4865_/A _4919_/S _4862_/B VDD VSS sg13cmos5l_xnor2_1
X_6601_ _6757_/B _6601_/A _6601_/B VDD VSS sg13cmos5l_nand2_2
XFILLER_60_461 VDD VSS sg13cmos5l_fill_1
XANTENNA_15 input31/X VDD VSS sg13cmos5l_antennanp
XANTENNA_26 _7719_/D VDD VSS sg13cmos5l_antennanp
X_4793_ _4843_/A _4793_/A _4793_/B VDD VSS sg13cmos5l_nor2_1
X_7581_ _7582_/B _7585_/A _7429_/B _7499_/B VDD VSS sg13cmos5l_o21ai_1
X_6532_ _6539_/A _6532_/A _6532_/B VDD VSS sg13cmos5l_nand2_2
X_6463_ _6464_/A _6847_/B _6847_/A VDD VSS sg13cmos5l_nand2_2
X_5414_ _5415_/B _5477_/B _5477_/A VDD VSS sg13cmos5l_xor2_1
Xoutput111 act_out[3] _6220_/Y VDD VSS sg13cmos5l_buf_1
Xoutput133 bank_A_rdata[25] _5143_/A VDD VSS sg13cmos5l_buf_1
Xoutput122 bank_A_rdata[15] _4522_/A VDD VSS sg13cmos5l_buf_1
X_6394_ _6396_/A _6394_/A _6826_/A VDD VSS sg13cmos5l_nand2_2
Xoutput144 bank_A_rdata[6] _4054_/A VDD VSS sg13cmos5l_buf_1
Xoutput166 bank_B_rdata[26] output166/A VDD VSS sg13cmos5l_buf_1
Xoutput155 bank_B_rdata[16] output155/A VDD VSS sg13cmos5l_buf_1
Xoutput177 bank_B_rdata[7] _6227_/B VDD VSS sg13cmos5l_buf_1
X_5345_ _5349_/A _5407_/B _5345_/B VDD VSS sg13cmos5l_xnor2_1
X_5276_ _5276_/Y _5276_/A _5276_/B VDD VSS sg13cmos5l_nor2_1
X_4227_ _4253_/B _4286_/B _4286_/A VDD VSS sg13cmos5l_xor2_1
X_7015_ _7016_/B _6829_/B _6995_/X _7014_/Y VDD VSS sg13cmos5l_a21oi_1
X_4158_ _4313_/A _5978_/B _4158_/B VDD VSS sg13cmos5l_nor2_1
XFILLER_56_756 VDD VSS sg13cmos5l_decap_4
XFILLER_102_11 VDD VSS sg13cmos5l_decap_8
X_4089_ _4090_/B _4262_/A _3950_/A _4205_/A _3981_/A VDD VSS sg13cmos5l_a22oi_1
XFILLER_71_704 VDD VSS sg13cmos5l_decap_4
XFILLER_51_483 VDD VSS sg13cmos5l_fill_1
XFILLER_78_325 VDD VSS sg13cmos5l_decap_8
XFILLER_78_369 VDD VSS sg13cmos5l_fill_2
XFILLER_78_358 VDD VSS sg13cmos5l_decap_8
Xfanout393 fanout393/X input107/X VDD VSS sg13cmos5l_buf_1
Xfanout371 _3972_/A _3929_/X VDD VSS sg13cmos5l_buf_1
Xfanout382 fanout382/X fanout383/X VDD VSS sg13cmos5l_buf_1
XFILLER_46_200 VDD VSS sg13cmos5l_fill_1
Xfanout360 _6915_/A _6231_/X VDD VSS sg13cmos5l_buf_16
XFILLER_74_542 VDD VSS sg13cmos5l_fill_2
XFILLER_36_60 VDD VSS sg13cmos5l_decap_8
XFILLER_61_225 VDD VSS sg13cmos5l_fill_2
XFILLER_62_726 VDD VSS sg13cmos5l_decap_4
XFILLER_42_450 VDD VSS sg13cmos5l_decap_4
XFILLER_52_92 VDD VSS sg13cmos5l_fill_2
Xinput13 input13/X bank_A_wdata[13] VDD VSS sg13cmos5l_buf_1
Xinput24 input24/X bank_A_wdata[23] VDD VSS sg13cmos5l_buf_1
Xinput46 _6199_/B bank_B_addr[4] VDD VSS sg13cmos5l_buf_1
Xinput35 input35/X bank_A_wdata[4] VDD VSS sg13cmos5l_buf_1
Xinput79 input79/X bank_B_wdata[7] VDD VSS sg13cmos5l_buf_1
Xinput57 input57/X bank_B_wdata[16] VDD VSS sg13cmos5l_buf_1
Xinput68 input68/X bank_B_wdata[26] VDD VSS sg13cmos5l_buf_1
X_5130_ _5137_/A _5630_/A _5130_/B VDD VSS sg13cmos5l_xnor2_1
X_5061_ _5062_/B _5370_/B1 _5568_/A _5310_/B1 _5569_/A VDD VSS sg13cmos5l_a22oi_1
XFILLER_78_892 VDD VSS sg13cmos5l_fill_1
X_4012_ _4015_/A _4012_/A _4012_/B VDD VSS sg13cmos5l_xor2_1
XFILLER_37_200 VDD VSS sg13cmos5l_decap_8
XFILLER_37_255 VDD VSS sg13cmos5l_decap_8
XFILLER_53_715 VDD VSS sg13cmos5l_decap_8
X_5963_ _6005_/A _5921_/B _5961_/Y _5962_/Y VDD VSS sg13cmos5l_a21oi_1
XFILLER_80_567 VDD VSS sg13cmos5l_fill_2
X_7702_ _7702_/Q _7704_/CLK _7702_/D fanout393/X VDD VSS sg13cmos5l_dfrbpq_1
X_4914_ _4972_/A _4914_/A _4909_/A VDD VSS sg13cmos5l_nor2b_1
XFILLER_80_589 VDD VSS sg13cmos5l_decap_8
X_5894_ _5961_/A _5866_/B _5866_/A _5893_/Y VDD VSS sg13cmos5l_a21oi_1
X_7633_ _7658_/B _7633_/A VDD VSS sg13cmos5l_buf_8
X_4845_ _4849_/A _4845_/A VDD VSS sg13cmos5l_inv_1
XFILLER_61_792 VDD VSS sg13cmos5l_decap_8
X_7564_ _7565_/C _7563_/Y _7564_/B VDD VSS sg13cmos5l_nand2b_1
X_4776_ _4777_/B _4776_/A _4838_/B VDD VSS sg13cmos5l_xor2_1
X_6515_ _6883_/B _6515_/A _6515_/B VDD VSS sg13cmos5l_nand2_2
X_7495_ _7628_/A _7495_/A _7492_/A VDD VSS sg13cmos5l_nor2b_1
X_6446_ _6447_/B _6444_/B _7676_/Q VDD VSS sg13cmos5l_nand2b_1
X_6377_ _6663_/B _6982_/A _6377_/B VDD VSS sg13cmos5l_nor2_1
X_5328_ _5328_/Y _5328_/A _5328_/B VDD VSS sg13cmos5l_nor2_1
XFILLER_76_829 VDD VSS sg13cmos5l_fill_1
XFILLER_75_328 VDD VSS sg13cmos5l_fill_2
XFILLER_69_881 VDD VSS sg13cmos5l_decap_8
X_5259_ _5259_/X _5259_/A VDD VSS sg13cmos5l_buf_1
XFILLER_56_531 VDD VSS sg13cmos5l_decap_4
XFILLER_44_704 VDD VSS sg13cmos5l_fill_1
XFILLER_71_545 VDD VSS sg13cmos5l_decap_4
XFILLER_40_910 VDD VSS sg13cmos5l_decap_8
XFILLER_98_11 VDD VSS sg13cmos5l_decap_8
XFILLER_78_122 VDD VSS sg13cmos5l_decap_8
XFILLER_78_166 VDD VSS sg13cmos5l_decap_8
XFILLER_78_199 VDD VSS sg13cmos5l_decap_8
Xfanout190 _6026_/B2 _5683_/X VDD VSS sg13cmos5l_buf_1
XFILLER_47_542 VDD VSS sg13cmos5l_fill_1
XFILLER_35_726 VDD VSS sg13cmos5l_decap_4
XFILLER_62_534 VDD VSS sg13cmos5l_fill_2
XFILLER_62_545 VDD VSS sg13cmos5l_fill_2
XFILLER_63_91 VDD VSS sg13cmos5l_decap_8
X_4630_ _4637_/A _5060_/A _4630_/B VDD VSS sg13cmos5l_xnor2_1
X_6300_ _6301_/B _6298_/A _7662_/Q VDD VSS sg13cmos5l_nand2b_1
X_4561_ _4561_/X _4561_/A VDD VSS sg13cmos5l_buf_1
X_7280_ _7281_/B _7280_/A1 _7276_/X _7279_/Y VDD VSS sg13cmos5l_o21ai_1
X_4492_ _4560_/A _4492_/A _4492_/B VDD VSS sg13cmos5l_xnor2_1
X_6231_ _6231_/X _7707_/Q VDD VSS sg13cmos5l_buf_16
X_6162_ _6165_/A _6160_/B _6159_/Y _6160_/Y _6161_/Y VDD VSS sg13cmos5l_a22oi_1
X_5113_ _5113_/Y _5113_/A _5056_/A VDD VSS sg13cmos5l_nor2b_1
XFILLER_69_155 VDD VSS sg13cmos5l_decap_8
X_6093_ _6095_/A _6093_/A _6093_/B VDD VSS sg13cmos5l_nand2_1
XFILLER_57_306 VDD VSS sg13cmos5l_decap_8
X_5044_ _5418_/A _5044_/A VDD VSS sg13cmos5l_buf_1
X_6995_ _6995_/X _7004_/A VDD VSS sg13cmos5l_buf_1
XFILLER_80_353 VDD VSS sg13cmos5l_decap_8
XFILLER_41_718 VDD VSS sg13cmos5l_fill_2
X_5946_ _5947_/A _5946_/A _5990_/A VDD VSS sg13cmos5l_xnor2_1
X_5877_ _5878_/B _5816_/B _5816_/A _5876_/X VDD VSS sg13cmos5l_a21o_1
XFILLER_40_239 VDD VSS sg13cmos5l_decap_8
X_7616_ _7617_/C _7616_/A _7616_/B _7616_/C VDD VSS sg13cmos5l_nor3_1
X_4828_ _4882_/A _5206_/B _5131_/A _4827_/Y VDD VSS sg13cmos5l_a21o_1
Xrebuffer724 rebuffer724/X _6661_/A VDD VSS sg13cmos5l_buf_1
Xrebuffer702 rebuffer702/X rebuffer703/X VDD VSS sg13cmos5l_buf_1
Xrebuffer713 rebuffer713/X rebuffer714/X VDD VSS sg13cmos5l_buf_1
X_7547_ _7548_/B _7547_/A _7550_/A VDD VSS sg13cmos5l_nand2_1
Xrebuffer757 _7530_/B _7272_/A VDD VSS sg13cmos5l_buf_1
X_4759_ _4759_/Y _4759_/A _4759_/B VDD VSS sg13cmos5l_nor2_1
Xrebuffer735 rebuffer735/X rebuffer736/X VDD VSS sg13cmos5l_buf_1
Xrebuffer746 rebuffer746/X rebuffer747/X VDD VSS sg13cmos5l_buf_1
Xrebuffer768 _6798_/B _6299_/B VDD VSS sg13cmos5l_buf_1
X_7478_ _7605_/C _7603_/A _7478_/B VDD VSS sg13cmos5l_xnor2_1
Xrebuffer779 _7494_/A1 _7453_/A VDD VSS sg13cmos5l_buf_1
X_6429_ _6431_/B _6541_/A _6565_/C VDD VSS sg13cmos5l_nand2_1
XFILLER_68_69 VDD VSS sg13cmos5l_fill_1
XFILLER_49_829 VDD VSS sg13cmos5l_fill_1
Xbank_B_sram.gen_ihp_256x32.u_sram_256x32_610 bank_B_sram.gen_ihp_256x32.u_sram_256x32_610/L_HI
+ VDD VSS sg13cmos5l_tiehi
XFILLER_72_843 VDD VSS sg13cmos5l_fill_1
XFILLER_44_545 VDD VSS sg13cmos5l_fill_1
XFILLER_72_887 VDD VSS sg13cmos5l_decap_8
XFILLER_40_740 VDD VSS sg13cmos5l_decap_8
XFILLER_79_464 VDD VSS sg13cmos5l_fill_2
XFILLER_79_453 VDD VSS sg13cmos5l_decap_8
XFILLER_67_604 VDD VSS sg13cmos5l_decap_8
XFILLER_79_486 VDD VSS sg13cmos5l_decap_8
XFILLER_48_873 VDD VSS sg13cmos5l_fill_2
XFILLER_81_128 VDD VSS sg13cmos5l_decap_8
XFILLER_35_556 VDD VSS sg13cmos5l_fill_2
X_3992_ _4012_/A _4168_/A VDD VSS sg13cmos5l_buf_1
X_6780_ _6899_/A _6780_/A _6780_/B _6780_/C VDD VSS sg13cmos5l_nand3_1
X_5800_ _5854_/A _5800_/A _5800_/B VDD VSS sg13cmos5l_xor2_1
X_5731_ _5786_/B _5731_/A _5731_/B _5731_/C VDD VSS sg13cmos5l_nand3_1
X_5662_ _5665_/A _5662_/A VDD VSS sg13cmos5l_inv_1
X_5593_ _5655_/A _5593_/A _5654_/A VDD VSS sg13cmos5l_xor2_1
X_4613_ _7675_/D _4613_/A _4613_/B VDD VSS sg13cmos5l_xor2_1
X_7401_ _7578_/A _7424_/A _7409_/B VDD VSS sg13cmos5l_xnor2_1
X_7332_ _7337_/A _7332_/A _7548_/A _7332_/C VDD VSS sg13cmos5l_nand3_1
X_4544_ _4611_/A _4544_/A _4549_/A VDD VSS sg13cmos5l_xnor2_1
X_7263_ _7263_/Y _7109_/B _7276_/S _7262_/X VDD VSS sg13cmos5l_a21oi_1
X_6214_ _6214_/Y _6185_/X _6183_/Y _6213_/Y VDD VSS sg13cmos5l_o21ai_1
X_4475_ _4479_/A _4475_/A _4475_/B VDD VSS sg13cmos5l_nand2_2
X_7194_ _7277_/A _7162_/B _7063_/Y _7193_/Y VDD VSS sg13cmos5l_a21oi_1
X_6145_ _6145_/Y _6145_/A _6145_/B VDD VSS sg13cmos5l_nor2_1
XFILLER_38_39 VDD VSS sg13cmos5l_decap_8
X_6076_ _6077_/B _6076_/A _6076_/B VDD VSS sg13cmos5l_nand2_1
XFILLER_57_114 VDD VSS sg13cmos5l_fill_1
XFILLER_73_618 VDD VSS sg13cmos5l_fill_1
X_5027_ _5096_/A _5025_/Y _4957_/B _5026_/Y VDD VSS sg13cmos5l_o21ai_1
XFILLER_57_169 VDD VSS sg13cmos5l_decap_8
XFILLER_72_106 VDD VSS sg13cmos5l_fill_1
XFILLER_39_873 VDD VSS sg13cmos5l_decap_8
XFILLER_38_350 VDD VSS sg13cmos5l_decap_8
XFILLER_53_342 VDD VSS sg13cmos5l_decap_8
XFILLER_65_180 VDD VSS sg13cmos5l_decap_8
XFILLER_81_673 VDD VSS sg13cmos5l_decap_8
XFILLER_80_150 VDD VSS sg13cmos5l_decap_8
XFILLER_53_353 VDD VSS sg13cmos5l_fill_2
XFILLER_54_876 VDD VSS sg13cmos5l_fill_2
XFILLER_110_11 VDD VSS sg13cmos5l_decap_8
XFILLER_41_537 VDD VSS sg13cmos5l_fill_2
X_6978_ _6979_/D _6800_/B _6978_/B VDD VSS sg13cmos5l_nand2b_1
X_5929_ _5930_/B _6042_/A _5884_/B _5928_/Y VDD VSS sg13cmos5l_o21ai_1
XFILLER_79_68 VDD VSS sg13cmos5l_fill_2
XFILLER_79_57 VDD VSS sg13cmos5l_decap_8
Xbank_A_sram.gen_ihp_256x32.u_sram_256x32_403 bank_A_sram.gen_ihp_256x32.u_sram_256x32_403/L_LO
+ VDD VSS sg13cmos5l_tielo
Xbank_A_sram.gen_ihp_256x32.u_sram_256x32_414 bank_A_sram.gen_ihp_256x32.u_sram_256x32_414/L_LO
+ VDD VSS sg13cmos5l_tielo
Xbank_A_sram.gen_ihp_256x32.u_sram_256x32_425 bank_A_sram.gen_ihp_256x32.u_sram_256x32_425/L_LO
+ VDD VSS sg13cmos5l_tielo
XFILLER_77_902 VDD VSS sg13cmos5l_fill_1
Xbank_A_sram.gen_ihp_256x32.u_sram_256x32_436 bank_A_sram.gen_ihp_256x32.u_sram_256x32_436/L_LO
+ VDD VSS sg13cmos5l_tielo
Xbank_A_sram.gen_ihp_256x32.u_sram_256x32_447 bank_A_sram.gen_ihp_256x32.u_sram_256x32_447/L_LO
+ VDD VSS sg13cmos5l_tielo
Xbank_A_sram.gen_ihp_256x32.u_sram_256x32_469 bank_A_sram.gen_ihp_256x32.u_sram_256x32_469/L_LO
+ VDD VSS sg13cmos5l_tielo
Xbank_A_sram.gen_ihp_256x32.u_sram_256x32_458 bank_A_sram.gen_ihp_256x32.u_sram_256x32_458/L_LO
+ VDD VSS sg13cmos5l_tielo
XFILLER_49_626 VDD VSS sg13cmos5l_decap_8
XFILLER_48_147 VDD VSS sg13cmos5l_decap_8
XFILLER_71_172 VDD VSS sg13cmos5l_decap_4
Xbank_B_sram.gen_ihp_256x32.u_sram_256x32_484 bank_B_sram.gen_ihp_256x32.u_sram_256x32_484/L_LO
+ VDD VSS sg13cmos5l_tielo
Xbank_B_sram.gen_ihp_256x32.u_sram_256x32_473 bank_B_sram.gen_ihp_256x32.u_sram_256x32_473/L_LO
+ VDD VSS sg13cmos5l_tielo
Xbank_B_sram.gen_ihp_256x32.u_sram_256x32_495 bank_B_sram.gen_ihp_256x32.u_sram_256x32_495/L_LO
+ VDD VSS sg13cmos5l_tielo
XFILLER_44_71 VDD VSS sg13cmos5l_fill_1
XFILLER_40_570 VDD VSS sg13cmos5l_decap_4
X_4260_ _4261_/B _3965_/B _4429_/A _4303_/B _4430_/A VDD VSS sg13cmos5l_a22oi_1
X_4191_ _7668_/D _4191_/A _4241_/A VDD VSS sg13cmos5l_xnor2_1
XFILLER_79_261 VDD VSS sg13cmos5l_decap_8
XFILLER_67_434 VDD VSS sg13cmos5l_fill_1
XFILLER_82_415 VDD VSS sg13cmos5l_decap_4
XFILLER_67_489 VDD VSS sg13cmos5l_fill_2
XFILLER_36_821 VDD VSS sg13cmos5l_fill_2
XFILLER_54_106 VDD VSS sg13cmos5l_decap_4
XFILLER_55_618 VDD VSS sg13cmos5l_decap_8
X_6901_ _6901_/Y _6939_/A _6901_/B VDD VSS sg13cmos5l_nor2_1
XFILLER_36_865 VDD VSS sg13cmos5l_decap_8
X_6832_ _6833_/B _6900_/C _7114_/A _6831_/Y VDD VSS sg13cmos5l_o21ai_1
XFILLER_35_386 VDD VSS sg13cmos5l_fill_1
X_3975_ _3976_/C _4155_/A VDD VSS sg13cmos5l_inv_1
XFILLER_50_367 VDD VSS sg13cmos5l_fill_2
X_6763_ _6965_/A _6951_/A VDD VSS sg13cmos5l_buf_1
X_5714_ _5753_/B _5810_/B _5714_/B VDD VSS sg13cmos5l_xnor2_1
X_6694_ _6780_/B _6692_/B _7705_/Q VDD VSS sg13cmos5l_nand2b_2
X_5645_ _5646_/B _5645_/A _5645_/B VDD VSS sg13cmos5l_xnor2_1
XFILLER_40_29 VDD VSS sg13cmos5l_decap_8
X_5576_ _5626_/B _5872_/A _5576_/B VDD VSS sg13cmos5l_xnor2_1
X_4527_ _4581_/A _4647_/B _4811_/A _4526_/Y VDD VSS sg13cmos5l_a21o_1
X_7315_ _7324_/A _7327_/A _6892_/Y _7314_/Y VDD VSS sg13cmos5l_o21ai_1
X_7246_ _7246_/Y _7246_/A _7246_/B VDD VSS sg13cmos5l_nor2_1
X_4458_ _4539_/A _4397_/A _4456_/Y _4457_/Y VDD VSS sg13cmos5l_o21ai_1
Xrebuffer1231 _4191_/A _4188_/X VDD VSS sg13cmos5l_buf_1
X_7177_ _7203_/B _7177_/A _7177_/B _7650_/B VDD VSS sg13cmos5l_nand3_1
Xrebuffer1242 rebuffer1242/X rebuffer1243/X VDD VSS sg13cmos5l_buf_1
Xrebuffer1220 rebuffer1220/X rebuffer1221/X VDD VSS sg13cmos5l_buf_1
XFILLER_105_11 VDD VSS sg13cmos5l_decap_8
X_4389_ _4390_/C _4750_/A VDD VSS sg13cmos5l_inv_1
X_6128_ _6155_/B _6128_/A _6128_/B VDD VSS sg13cmos5l_xnor2_1
XFILLER_58_445 VDD VSS sg13cmos5l_decap_8
XFILLER_39_681 VDD VSS sg13cmos5l_decap_8
XFILLER_45_117 VDD VSS sg13cmos5l_fill_1
X_6059_ _6060_/B _6114_/B _5685_/X _6082_/A1 _5686_/X VDD VSS sg13cmos5l_a22oi_1
XFILLER_73_459 VDD VSS sg13cmos5l_fill_1
XFILLER_42_802 VDD VSS sg13cmos5l_fill_1
XFILLER_41_312 VDD VSS sg13cmos5l_decap_8
XFILLER_100_0 VDD VSS sg13cmos5l_decap_8
XFILLER_49_412 VDD VSS sg13cmos5l_fill_1
XFILLER_76_231 VDD VSS sg13cmos5l_fill_2
XFILLER_39_71 VDD VSS sg13cmos5l_decap_8
XFILLER_76_264 VDD VSS sg13cmos5l_decap_4
XFILLER_64_426 VDD VSS sg13cmos5l_decap_8
XFILLER_72_481 VDD VSS sg13cmos5l_decap_8
XFILLER_60_687 VDD VSS sg13cmos5l_decap_8
X_5430_ _5492_/S _5493_/B1 _5858_/A _5430_/B1 _5116_/X VDD VSS sg13cmos5l_a22oi_1
X_5361_ _5362_/B _5359_/Y _5361_/B VDD VSS sg13cmos5l_nand2b_1
X_5292_ _5292_/X _5292_/A _5292_/B VDD VSS sg13cmos5l_and2_1
X_7100_ _7262_/A _6775_/B _7164_/A _7099_/Y VDD VSS sg13cmos5l_a21oi_1
X_4312_ _4369_/A _4312_/A _4312_/B VDD VSS sg13cmos5l_xnor2_1
X_4243_ _4244_/B _4243_/A _4243_/B _4243_/C VDD VSS sg13cmos5l_nand3_1
X_7031_ _7031_/Y _7030_/B _7027_/Y _7030_/Y VDD VSS sg13cmos5l_o21ai_1
X_4174_ _4212_/A _4172_/B _4433_/A _4173_/Y VDD VSS sg13cmos5l_a21o_1
XFILLER_68_776 VDD VSS sg13cmos5l_decap_8
XFILLER_36_651 VDD VSS sg13cmos5l_decap_8
XFILLER_82_289 VDD VSS sg13cmos5l_decap_4
XFILLER_35_172 VDD VSS sg13cmos5l_decap_4
XFILLER_63_470 VDD VSS sg13cmos5l_decap_8
X_6815_ _6816_/A _6815_/A _6815_/B VDD VSS sg13cmos5l_xnor2_1
X_6746_ _6997_/B _6813_/S _6741_/Y _6745_/Y VDD VSS sg13cmos5l_o21ai_1
XFILLER_50_175 VDD VSS sg13cmos5l_fill_1
X_3958_ _3963_/A _3958_/A VDD VSS sg13cmos5l_buf_8
XFILLER_50_186 VDD VSS sg13cmos5l_decap_8
X_6677_ _6678_/A _6677_/A _6677_/B _6742_/B VDD VSS sg13cmos5l_nand3_1
X_5628_ _5629_/B _5628_/A _5680_/A VDD VSS sg13cmos5l_xnor2_1
X_5559_ _5560_/B _5559_/A _5559_/B VDD VSS sg13cmos5l_xnor2_1
X_7229_ _7230_/A _7292_/A _7244_/A VDD VSS sg13cmos5l_nor2_1
XFILLER_59_710 VDD VSS sg13cmos5l_fill_2
XFILLER_59_754 VDD VSS sg13cmos5l_fill_1
XFILLER_47_927 VDD VSS sg13cmos5l_decap_8
XFILLER_58_253 VDD VSS sg13cmos5l_fill_1
XFILLER_74_757 VDD VSS sg13cmos5l_decap_8
XFILLER_73_223 VDD VSS sg13cmos5l_decap_8
XFILLER_46_448 VDD VSS sg13cmos5l_fill_1
XFILLER_58_297 VDD VSS sg13cmos5l_decap_8
XFILLER_73_278 VDD VSS sg13cmos5l_decap_8
XFILLER_61_418 VDD VSS sg13cmos5l_decap_8
XFILLER_62_919 VDD VSS sg13cmos5l_fill_1
XFILLER_54_470 VDD VSS sg13cmos5l_fill_2
XFILLER_41_94 VDD VSS sg13cmos5l_decap_8
XFILLER_44_8 VDD VSS sg13cmos5l_fill_2
XFILLER_77_551 VDD VSS sg13cmos5l_decap_8
XFILLER_38_927 VDD VSS sg13cmos5l_decap_8
XFILLER_37_415 VDD VSS sg13cmos5l_decap_8
XFILLER_49_297 VDD VSS sg13cmos5l_decap_4
XFILLER_53_908 VDD VSS sg13cmos5l_fill_1
XFILLER_64_256 VDD VSS sg13cmos5l_decap_4
X_4930_ _4931_/B _5244_/B1 _4996_/A _5178_/B1 _4997_/A VDD VSS sg13cmos5l_a22oi_1
X_4861_ _4862_/B _4922_/A _4861_/B VDD VSS sg13cmos5l_xnor2_1
X_6600_ _6601_/A _6600_/A _6764_/A VDD VSS sg13cmos5l_nand2_2
XANTENNA_16 input35/X VDD VSS sg13cmos5l_antennanp
XANTENNA_27 input58/X VDD VSS sg13cmos5l_antennanp
X_4792_ _4793_/B _4792_/A VDD VSS sg13cmos5l_inv_1
X_7580_ _7584_/A _7580_/A _7623_/B _7623_/C _7623_/A VDD VSS sg13cmos5l_nand4_1
X_6531_ _6532_/A _6531_/A _6882_/A VDD VSS sg13cmos5l_nand2_2
X_6462_ _6847_/A _6462_/A _6464_/B VDD VSS sg13cmos5l_nor2b_1
X_5413_ _5477_/A _5349_/B _5349_/A _5412_/Y VDD VSS sg13cmos5l_a21o_1
X_6393_ _6826_/A _7671_/Q _6393_/B VDD VSS sg13cmos5l_xnor2_1
Xoutput112 act_out[4] _6222_/Y VDD VSS sg13cmos5l_buf_1
Xoutput134 bank_A_rdata[26] _5203_/A VDD VSS sg13cmos5l_buf_1
Xoutput123 bank_A_rdata[16] _4586_/A VDD VSS sg13cmos5l_buf_1
X_5344_ _5345_/B _5344_/A _5408_/B VDD VSS sg13cmos5l_xor2_1
Xoutput145 bank_A_rdata[7] _4083_/A VDD VSS sg13cmos5l_buf_1
Xoutput167 bank_B_rdata[27] output167/A VDD VSS sg13cmos5l_buf_1
Xoutput156 bank_B_rdata[17] output156/A VDD VSS sg13cmos5l_buf_1
X_5275_ _5276_/B _5460_/A _5460_/B _5275_/C VDD VSS sg13cmos5l_nor3_1
Xoutput178 bank_B_rdata[8] output178/A VDD VSS sg13cmos5l_buf_1
X_4226_ _4286_/A _4226_/A _4285_/A VDD VSS sg13cmos5l_xnor2_1
X_7014_ _7014_/Y _7044_/A _7014_/B VDD VSS sg13cmos5l_nor2_1
XFILLER_68_584 VDD VSS sg13cmos5l_decap_8
XFILLER_68_573 VDD VSS sg13cmos5l_fill_2
X_4157_ _4194_/A _4207_/A _4157_/B VDD VSS sg13cmos5l_xnor2_1
X_4088_ _4120_/A _3956_/X _4310_/A _4087_/Y VDD VSS sg13cmos5l_a21o_1
XFILLER_52_930 VDD VSS sg13cmos5l_decap_4
XFILLER_64_790 VDD VSS sg13cmos5l_decap_8
XFILLER_62_16 VDD VSS sg13cmos5l_decap_8
X_6729_ _7210_/A _7105_/A _6900_/C _7105_/B VDD VSS sg13cmos5l_nand3_1
XFILLER_2_4 VDD VSS sg13cmos5l_decap_4
XFILLER_78_304 VDD VSS sg13cmos5l_decap_8
Xfanout350 _4528_/A _4223_/A VDD VSS sg13cmos5l_buf_1
Xfanout361 _6219_/A _6212_/X VDD VSS sg13cmos5l_buf_1
Xfanout383 fanout383/X fanout392/X VDD VSS sg13cmos5l_buf_1
XFILLER_61_215 VDD VSS sg13cmos5l_fill_1
XFILLER_61_237 VDD VSS sg13cmos5l_fill_2
Xinput25 input25/X bank_A_wdata[24] VDD VSS sg13cmos5l_buf_1
Xinput36 input36/X bank_A_wdata[5] VDD VSS sg13cmos5l_buf_1
Xinput14 input14/X bank_A_wdata[14] VDD VSS sg13cmos5l_buf_1
Xinput47 _6202_/B bank_B_addr[5] VDD VSS sg13cmos5l_buf_1
Xinput58 input58/X bank_B_wdata[17] VDD VSS sg13cmos5l_buf_1
Xinput69 input69/X bank_B_wdata[27] VDD VSS sg13cmos5l_buf_1
XFILLER_69_348 VDD VSS sg13cmos5l_fill_2
X_5060_ _5321_/A _5060_/A VDD VSS sg13cmos5l_buf_1
X_4011_ _4012_/B _4037_/B _4037_/A VDD VSS sg13cmos5l_xor2_1
XFILLER_38_713 VDD VSS sg13cmos5l_fill_2
X_5962_ _5962_/Y _5962_/A _5962_/B VDD VSS sg13cmos5l_nor2_1
XFILLER_53_749 VDD VSS sg13cmos5l_decap_4
XFILLER_65_598 VDD VSS sg13cmos5l_fill_1
X_7701_ _7701_/Q _7704_/CLK _7701_/D fanout393/X VDD VSS sg13cmos5l_dfrbpq_1
X_4913_ _7680_/D _4975_/B _4975_/A VDD VSS sg13cmos5l_xor2_1
X_5893_ _5893_/Y _5893_/A _5865_/A VDD VSS sg13cmos5l_nor2b_1
X_7632_ _7633_/A _7609_/A _7632_/B VDD VSS sg13cmos5l_nand2b_1
X_4844_ _4845_/A _4844_/A _4844_/B VDD VSS sg13cmos5l_xor2_1
XFILLER_60_292 VDD VSS sg13cmos5l_decap_8
X_7563_ _7563_/Y _7563_/A1 _7513_/A _7368_/B VDD VSS sg13cmos5l_a21oi_1
X_4775_ _4838_/B _4775_/A _4775_/B VDD VSS sg13cmos5l_xor2_1
X_6514_ _6515_/B _6512_/B _7684_/Q VDD VSS sg13cmos5l_nand2b_1
X_7494_ _7495_/A _7494_/A1 _7589_/B _7453_/B VDD VSS sg13cmos5l_a21oi_1
X_6445_ _6447_/A _6445_/A _6851_/A VDD VSS sg13cmos5l_nand2_2
X_6376_ _6377_/B _6376_/A _6720_/A _6909_/B VDD VSS sg13cmos5l_nand3_1
X_5327_ _5343_/A _5327_/A _5327_/B VDD VSS sg13cmos5l_xor2_1
XFILLER_57_38 VDD VSS sg13cmos5l_decap_4
X_5258_ _5258_/X _5258_/A VDD VSS sg13cmos5l_buf_1
XFILLER_113_22 VDD VSS sg13cmos5l_decap_8
XFILLER_68_381 VDD VSS sg13cmos5l_fill_1
X_4209_ _4210_/B _4266_/A _4209_/B VDD VSS sg13cmos5l_xnor2_1
X_5189_ _5196_/A _5630_/A _5189_/B VDD VSS sg13cmos5l_xnor2_1
XFILLER_71_502 VDD VSS sg13cmos5l_decap_8
XFILLER_56_576 VDD VSS sg13cmos5l_decap_8
XFILLER_56_587 VDD VSS sg13cmos5l_fill_1
XFILLER_52_771 VDD VSS sg13cmos5l_fill_2
XFILLER_40_933 VDD VSS sg13cmos5l_fill_1
XFILLER_52_793 VDD VSS sg13cmos5l_decap_4
XFILLER_78_101 VDD VSS sg13cmos5l_decap_8
XFILLER_67_808 VDD VSS sg13cmos5l_fill_1
Xfanout180 _7377_/B _7343_/X VDD VSS sg13cmos5l_buf_1
Xfanout191 _7276_/S _7296_/A VDD VSS sg13cmos5l_buf_1
XFILLER_74_340 VDD VSS sg13cmos5l_decap_8
XFILLER_74_362 VDD VSS sg13cmos5l_decap_4
XFILLER_35_716 VDD VSS sg13cmos5l_decap_4
XFILLER_50_708 VDD VSS sg13cmos5l_fill_1
XFILLER_62_557 VDD VSS sg13cmos5l_fill_1
XFILLER_43_760 VDD VSS sg13cmos5l_decap_8
XFILLER_63_70 VDD VSS sg13cmos5l_fill_1
XFILLER_42_281 VDD VSS sg13cmos5l_fill_2
X_4560_ _4571_/A _4560_/A _4560_/B VDD VSS sg13cmos5l_nor2_1
X_4491_ _4492_/B _4675_/B1 _4563_/A _3964_/C _4564_/A VDD VSS sg13cmos5l_a22oi_1
X_6230_ _6768_/A _7708_/Q VDD VSS sg13cmos5l_buf_16
XFILLER_69_101 VDD VSS sg13cmos5l_fill_1
X_6161_ _6161_/Y _6138_/B _6139_/B _6159_/Y VDD VSS sg13cmos5l_a21oi_1
XFILLER_69_123 VDD VSS sg13cmos5l_fill_1
X_5112_ _5172_/A _5171_/B _5302_/A VDD VSS sg13cmos5l_nand2_1
X_6092_ _6096_/A _6092_/A VDD VSS sg13cmos5l_inv_1
XFILLER_57_318 VDD VSS sg13cmos5l_fill_1
X_5043_ _5108_/B _5043_/A _5043_/B VDD VSS sg13cmos5l_nand2_1
XFILLER_65_384 VDD VSS sg13cmos5l_decap_4
XFILLER_80_332 VDD VSS sg13cmos5l_decap_8
X_6994_ _7233_/A _6994_/A _7080_/A VDD VSS sg13cmos5l_nand2_2
X_5945_ _5990_/A _5945_/A _5989_/A VDD VSS sg13cmos5l_xor2_1
X_5876_ _5876_/X _5876_/A _5876_/B VDD VSS sg13cmos5l_and2_1
XFILLER_40_218 VDD VSS sg13cmos5l_decap_8
X_7615_ _7616_/B _7615_/A _7615_/B _7615_/C _7615_/D VDD VSS sg13cmos5l_nand4_1
X_4827_ _4827_/Y _4827_/A _4827_/B VDD VSS sg13cmos5l_nor2_1
Xrebuffer714 rebuffer714/X rebuffer715/X VDD VSS sg13cmos5l_buf_1
Xrebuffer703 rebuffer703/X rebuffer704/X VDD VSS sg13cmos5l_buf_1
X_7546_ _7561_/A _7616_/C _7613_/A _7613_/B _7546_/D VDD VSS sg13cmos5l_nand4_1
Xrebuffer758 _6988_/A _6985_/A VDD VSS sg13cmos5l_buf_1
Xrebuffer725 _7602_/A _7489_/Y VDD VSS sg13cmos5l_buf_1
Xrebuffer747 rebuffer747/X rebuffer748/X VDD VSS sg13cmos5l_buf_1
Xrebuffer736 rebuffer736/X rebuffer737/X VDD VSS sg13cmos5l_buf_1
X_4758_ _4775_/A _4758_/A _4758_/B VDD VSS sg13cmos5l_xor2_1
XFILLER_111_8 VDD VSS sg13cmos5l_decap_8
XFILLER_108_11 VDD VSS sg13cmos5l_decap_8
Xrebuffer769 _7150_/A _7121_/B VDD VSS sg13cmos5l_buf_1
X_7477_ _7605_/B _7603_/A _7477_/B VDD VSS sg13cmos5l_xnor2_1
X_4689_ _4690_/B _5244_/B1 _4751_/A _5178_/B1 _4752_/A VDD VSS sg13cmos5l_a22oi_1
X_6428_ _6465_/A _6428_/A VDD VSS sg13cmos5l_buf_1
X_6359_ _6361_/A _6368_/C _6368_/A VDD VSS sg13cmos5l_xnor2_1
XFILLER_75_126 VDD VSS sg13cmos5l_fill_1
Xbank_B_sram.gen_ihp_256x32.u_sram_256x32_600 bank_B_sram.gen_ihp_256x32.u_sram_256x32_600/L_HI
+ VDD VSS sg13cmos5l_tiehi
XFILLER_56_362 VDD VSS sg13cmos5l_decap_8
Xbank_B_sram.gen_ihp_256x32.u_sram_256x32_611 bank_B_sram.gen_ihp_256x32.u_sram_256x32_611/L_HI
+ VDD VSS sg13cmos5l_tiehi
XFILLER_71_354 VDD VSS sg13cmos5l_decap_8
XFILLER_79_432 VDD VSS sg13cmos5l_decap_8
XFILLER_66_104 VDD VSS sg13cmos5l_decap_8
XFILLER_66_115 VDD VSS sg13cmos5l_fill_1
XFILLER_81_107 VDD VSS sg13cmos5l_decap_8
XFILLER_75_671 VDD VSS sg13cmos5l_decap_8
XFILLER_48_896 VDD VSS sg13cmos5l_fill_2
XFILLER_63_811 VDD VSS sg13cmos5l_decap_8
XFILLER_62_321 VDD VSS sg13cmos5l_fill_1
XFILLER_62_310 VDD VSS sg13cmos5l_decap_8
X_3991_ _4272_/A _4043_/A VDD VSS sg13cmos5l_buf_1
X_5730_ _5736_/C _5731_/A _5731_/B _5731_/C VDD VSS sg13cmos5l_a21o_1
X_5661_ _5662_/A _5598_/B _5598_/A _5660_/Y VDD VSS sg13cmos5l_a21o_1
X_7400_ _7409_/B _7404_/A _7276_/X _7399_/Y VDD VSS sg13cmos5l_o21ai_1
X_5592_ _5654_/A _5592_/A _5592_/B VDD VSS sg13cmos5l_xnor2_1
X_4612_ _4613_/B _4545_/A _4611_/Y _4547_/Y VDD VSS sg13cmos5l_o21ai_1
X_7331_ _7332_/C _7323_/A _7352_/A VDD VSS sg13cmos5l_nand2b_1
X_4543_ _4549_/A _4550_/A _4551_/A VDD VSS sg13cmos5l_xnor2_1
X_7262_ _7262_/X _7262_/A _7294_/B VDD VSS sg13cmos5l_and2_1
X_6213_ _6213_/Y _6219_/A _6213_/B VDD VSS sg13cmos5l_nand2_1
X_4474_ _4478_/A _4547_/B _4479_/C VDD VSS sg13cmos5l_nand2_1
X_7193_ _7193_/Y _7071_/Y _7072_/Y _7162_/B VDD VSS sg13cmos5l_a21oi_1
XFILLER_38_18 VDD VSS sg13cmos5l_decap_8
X_6144_ _6144_/Y _6144_/A VDD VSS sg13cmos5l_inv_1
X_6075_ _6078_/A _6103_/B _6103_/A VDD VSS sg13cmos5l_xor2_1
X_5026_ _5026_/Y _4956_/A _5026_/B VDD VSS sg13cmos5l_nand2b_1
XFILLER_57_137 VDD VSS sg13cmos5l_fill_1
XFILLER_66_660 VDD VSS sg13cmos5l_fill_2
XFILLER_81_652 VDD VSS sg13cmos5l_decap_8
XFILLER_54_888 VDD VSS sg13cmos5l_decap_4
X_6977_ _6979_/C _6805_/Y _6977_/B VDD VSS sg13cmos5l_nand2b_1
XFILLER_41_527 VDD VSS sg13cmos5l_decap_4
X_5928_ _5928_/Y _5928_/A _5928_/B VDD VSS sg13cmos5l_nand2_1
X_5859_ _5908_/S _5909_/B1 _6114_/A _5859_/B1 _6026_/B2 VDD VSS sg13cmos5l_a22oi_1
X_7529_ _7613_/A _7529_/A _7529_/B VDD VSS sg13cmos5l_xor2_1
XFILLER_102_4 VDD VSS sg13cmos5l_decap_8
Xbank_A_sram.gen_ihp_256x32.u_sram_256x32_404 bank_A_sram.gen_ihp_256x32.u_sram_256x32_404/L_LO
+ VDD VSS sg13cmos5l_tielo
Xbank_A_sram.gen_ihp_256x32.u_sram_256x32_415 bank_A_sram.gen_ihp_256x32.u_sram_256x32_415/L_LO
+ VDD VSS sg13cmos5l_tielo
Xbank_A_sram.gen_ihp_256x32.u_sram_256x32_426 bank_A_sram.gen_ihp_256x32.u_sram_256x32_426/L_LO
+ VDD VSS sg13cmos5l_tielo
XFILLER_49_605 VDD VSS sg13cmos5l_decap_8
Xbank_A_sram.gen_ihp_256x32.u_sram_256x32_437 bank_A_sram.gen_ihp_256x32.u_sram_256x32_437/L_LO
+ VDD VSS sg13cmos5l_tielo
Xbank_A_sram.gen_ihp_256x32.u_sram_256x32_448 bank_A_sram.gen_ihp_256x32.u_sram_256x32_448/L_LO
+ VDD VSS sg13cmos5l_tielo
Xbank_A_sram.gen_ihp_256x32.u_sram_256x32_459 bank_A_sram.gen_ihp_256x32.u_sram_256x32_459/L_LO
+ VDD VSS sg13cmos5l_tielo
XFILLER_63_118 VDD VSS sg13cmos5l_fill_2
XFILLER_45_866 VDD VSS sg13cmos5l_decap_8
XFILLER_60_803 VDD VSS sg13cmos5l_fill_1
XFILLER_71_162 VDD VSS sg13cmos5l_fill_1
Xbank_B_sram.gen_ihp_256x32.u_sram_256x32_485 bank_B_sram.gen_ihp_256x32.u_sram_256x32_485/L_LO
+ VDD VSS sg13cmos5l_tielo
Xbank_B_sram.gen_ihp_256x32.u_sram_256x32_474 bank_B_sram.gen_ihp_256x32.u_sram_256x32_474/L_LO
+ VDD VSS sg13cmos5l_tielo
XFILLER_71_195 VDD VSS sg13cmos5l_fill_2
Xbank_B_sram.gen_ihp_256x32.u_sram_256x32_496 bank_B_sram.gen_ihp_256x32.u_sram_256x32_496/L_LO
+ VDD VSS sg13cmos5l_tielo
XFILLER_60_869 VDD VSS sg13cmos5l_fill_2
XFILLER_60_82 VDD VSS sg13cmos5l_fill_1
XFILLER_5_22 VDD VSS sg13cmos5l_decap_8
XFILLER_79_240 VDD VSS sg13cmos5l_decap_8
X_4190_ _4241_/A _4143_/Y _4144_/A _4189_/Y VDD VSS sg13cmos5l_a21oi_2
XFILLER_67_402 VDD VSS sg13cmos5l_decap_8
XFILLER_67_468 VDD VSS sg13cmos5l_fill_2
XFILLER_67_457 VDD VSS sg13cmos5l_decap_8
XFILLER_67_446 VDD VSS sg13cmos5l_fill_1
XFILLER_39_148 VDD VSS sg13cmos5l_decap_4
XFILLER_36_811 VDD VSS sg13cmos5l_decap_4
XFILLER_75_490 VDD VSS sg13cmos5l_decap_8
XFILLER_36_844 VDD VSS sg13cmos5l_decap_8
XFILLER_35_321 VDD VSS sg13cmos5l_decap_8
X_6900_ _6909_/A _6991_/B _6900_/B _6900_/C VDD VSS sg13cmos5l_nand3_1
X_6831_ _6831_/Y _6831_/A _6900_/C VDD VSS sg13cmos5l_nand2_1
X_3974_ _3977_/B _3972_/A _4155_/A _4525_/A VDD VSS sg13cmos5l_a21oi_1
X_6762_ _6762_/Y _7021_/A _7004_/B _6761_/Y VDD VSS sg13cmos5l_o21ai_1
XFILLER_50_346 VDD VSS sg13cmos5l_fill_2
X_5713_ _5714_/B _5755_/A _5756_/A2 _6082_/A1 _5756_/B2 VDD VSS sg13cmos5l_a22oi_1
X_6693_ _6780_/A _6716_/B _6716_/A VDD VSS sg13cmos5l_nand2_2
X_5644_ _5645_/B _6136_/B _5644_/A2 _5755_/A _5644_/B2 VDD VSS sg13cmos5l_a22oi_1
X_5575_ _5576_/B _5949_/B1 _5943_/A2 _5909_/B1 _5943_/B2 VDD VSS sg13cmos5l_a22oi_1
X_7314_ _7314_/Y _7312_/Y _7394_/A2 _7343_/A VDD VSS sg13cmos5l_a21oi_1
X_4526_ _4526_/Y _4526_/A _4526_/B VDD VSS sg13cmos5l_nor2_1
X_7245_ _7258_/A _7245_/A _7245_/B _7531_/B VDD VSS sg13cmos5l_nand3_1
Xrebuffer1210 _6016_/A rebuffer1237/X VDD VSS sg13cmos5l_buf_1
X_4457_ _4457_/Y _4457_/A _4457_/B VDD VSS sg13cmos5l_nand2_1
Xrebuffer1243 rebuffer1243/X rebuffer1244/X VDD VSS sg13cmos5l_buf_1
Xrebuffer1221 rebuffer1221/X rebuffer1222/X VDD VSS sg13cmos5l_buf_1
X_7176_ _7650_/B _7176_/A _7176_/B VDD VSS sg13cmos5l_nand2_1
Xrebuffer1232 _4976_/B _4975_/Y VDD VSS sg13cmos5l_buf_1
X_4388_ _4391_/A _3972_/A _4750_/A _4944_/A VDD VSS sg13cmos5l_a21oi_1
X_6127_ _6128_/B _6152_/B _6152_/A VDD VSS sg13cmos5l_xnor2_1
XFILLER_39_660 VDD VSS sg13cmos5l_decap_8
X_6058_ _6081_/S _6082_/B1 _6114_/A _6058_/B1 _5683_/X VDD VSS sg13cmos5l_a22oi_1
XFILLER_65_16 VDD VSS sg13cmos5l_fill_2
XFILLER_65_27 VDD VSS sg13cmos5l_decap_8
X_5009_ _5010_/B _5131_/A _5199_/A _5063_/A _5200_/A VDD VSS sg13cmos5l_a22oi_1
XFILLER_42_814 VDD VSS sg13cmos5l_fill_1
XFILLER_54_641 VDD VSS sg13cmos5l_decap_4
XFILLER_54_652 VDD VSS sg13cmos5l_decap_8
XFILLER_81_482 VDD VSS sg13cmos5l_fill_2
XFILLER_81_471 VDD VSS sg13cmos5l_decap_8
XFILLER_42_847 VDD VSS sg13cmos5l_decap_8
XFILLER_81_59 VDD VSS sg13cmos5l_decap_8
XFILLER_41_368 VDD VSS sg13cmos5l_fill_1
XFILLER_39_50 VDD VSS sg13cmos5l_decap_8
XFILLER_49_424 VDD VSS sg13cmos5l_decap_4
XFILLER_77_788 VDD VSS sg13cmos5l_fill_2
XFILLER_77_777 VDD VSS sg13cmos5l_decap_8
XFILLER_76_276 VDD VSS sg13cmos5l_decap_4
XFILLER_64_416 VDD VSS sg13cmos5l_fill_2
XFILLER_57_490 VDD VSS sg13cmos5l_fill_1
XFILLER_64_438 VDD VSS sg13cmos5l_decap_4
XFILLER_55_60 VDD VSS sg13cmos5l_decap_8
XFILLER_44_162 VDD VSS sg13cmos5l_fill_1
XFILLER_44_151 VDD VSS sg13cmos5l_decap_8
X_5360_ _5361_/B _5360_/A _5360_/B VDD VSS sg13cmos5l_nand2_2
X_4311_ _4312_/B _4859_/B1 _4047_/X _4799_/B1 _4752_/A VDD VSS sg13cmos5l_a22oi_1
X_5291_ _5294_/A _5303_/B _5303_/A VDD VSS sg13cmos5l_xor2_1
X_4242_ _4247_/A _4245_/B _4242_/B VDD VSS sg13cmos5l_nor2_1
X_7030_ _7030_/Y _7162_/A _7030_/B _7162_/C VDD VSS sg13cmos5l_nand3_1
X_4173_ _4173_/Y _4173_/A _4173_/B VDD VSS sg13cmos5l_nor2_1
XFILLER_68_755 VDD VSS sg13cmos5l_fill_2
XFILLER_68_744 VDD VSS sg13cmos5l_decap_8
XFILLER_56_906 VDD VSS sg13cmos5l_fill_2
XFILLER_82_246 VDD VSS sg13cmos5l_fill_1
X_6814_ _6962_/A _6814_/A _6814_/B VDD VSS sg13cmos5l_xnor2_1
XFILLER_35_195 VDD VSS sg13cmos5l_decap_4
X_3957_ _3957_/X _4172_/B VDD VSS sg13cmos5l_buf_1
X_6745_ _6745_/Y _6901_/B _6910_/S VDD VSS sg13cmos5l_nand2_1
X_6676_ _6742_/B _6676_/A _6676_/B VDD VSS sg13cmos5l_nand2_1
X_5627_ _5680_/A _5578_/B _5578_/A _5626_/X VDD VSS sg13cmos5l_a21oi_1
X_5558_ _5559_/B _5190_/X _5685_/A _5131_/X _5686_/A VDD VSS sg13cmos5l_a22oi_1
X_4509_ _4510_/B _4799_/B1 _4996_/A _4738_/B1 _4997_/A VDD VSS sg13cmos5l_a22oi_1
X_7228_ _7244_/A _6416_/A _7224_/Y _7227_/Y VDD VSS sg13cmos5l_o21ai_1
X_5489_ _5552_/A _5489_/A _5489_/B _5489_/C VDD VSS sg13cmos5l_nand3_1
XFILLER_76_37 VDD VSS sg13cmos5l_decap_8
X_7159_ _7159_/Y _7157_/Y _7280_/A1 _7059_/Y VDD VSS sg13cmos5l_a21oi_1
XFILLER_59_766 VDD VSS sg13cmos5l_decap_4
XFILLER_59_777 VDD VSS sg13cmos5l_decap_8
XFILLER_58_287 VDD VSS sg13cmos5l_fill_2
XFILLER_92_25 VDD VSS sg13cmos5l_decap_4
XFILLER_42_600 VDD VSS sg13cmos5l_decap_8
XFILLER_54_460 VDD VSS sg13cmos5l_fill_1
XFILLER_54_493 VDD VSS sg13cmos5l_fill_1
XFILLER_41_73 VDD VSS sg13cmos5l_decap_8
XFILLER_38_906 VDD VSS sg13cmos5l_decap_8
XFILLER_2_12 VDD VSS sg13cmos5l_decap_8
XFILLER_49_265 VDD VSS sg13cmos5l_fill_1
XFILLER_49_254 VDD VSS sg13cmos5l_decap_8
XFILLER_77_585 VDD VSS sg13cmos5l_decap_8
XFILLER_37_449 VDD VSS sg13cmos5l_fill_2
XFILLER_49_287 VDD VSS sg13cmos5l_fill_2
XFILLER_65_736 VDD VSS sg13cmos5l_fill_2
XFILLER_66_81 VDD VSS sg13cmos5l_decap_8
X_4860_ _4861_/B _5050_/B1 _4563_/X _4986_/B1 _4564_/X VDD VSS sg13cmos5l_a22oi_1
XFILLER_82_91 VDD VSS sg13cmos5l_fill_2
XANTENNA_28 _7711_/D VDD VSS sg13cmos5l_antennanp
X_6530_ _6882_/A _6530_/A _6532_/B VDD VSS sg13cmos5l_nor2b_1
XANTENNA_17 output151/A VDD VSS sg13cmos5l_antennanp
X_4791_ _4793_/A _4791_/A VDD VSS sg13cmos5l_inv_1
X_6461_ _6464_/B _6461_/A _7678_/Q _6461_/C VDD VSS sg13cmos5l_nand3_1
X_5412_ _5412_/Y _5412_/A _5350_/B VDD VSS sg13cmos5l_nor2b_1
X_6392_ _6393_/B _6388_/Y _6401_/B _6461_/C VDD VSS sg13cmos5l_o21ai_1
Xoutput113 act_out[5] _6224_/Y VDD VSS sg13cmos5l_buf_1
Xoutput124 bank_A_rdata[17] _4644_/A VDD VSS sg13cmos5l_buf_1
X_5343_ _5408_/B _5343_/A _5343_/B VDD VSS sg13cmos5l_xor2_1
Xoutput135 bank_A_rdata[27] _5272_/A VDD VSS sg13cmos5l_buf_1
Xoutput146 bank_A_rdata[8] _4125_/A VDD VSS sg13cmos5l_buf_1
Xoutput168 bank_B_rdata[28] output168/A VDD VSS sg13cmos5l_buf_1
Xoutput157 bank_B_rdata[18] output157/A VDD VSS sg13cmos5l_buf_1
X_5274_ _5275_/C _5633_/A VDD VSS sg13cmos5l_inv_1
Xoutput179 bank_B_rdata[9] output179/A VDD VSS sg13cmos5l_buf_1
X_4225_ _4285_/A _4225_/A _4225_/B VDD VSS sg13cmos5l_xor2_1
X_7013_ _7013_/Y _7071_/B _6825_/Y _7012_/Y VDD VSS sg13cmos5l_o21ai_1
X_4156_ _4157_/B _4675_/B1 _4047_/A _3964_/C _4076_/A VDD VSS sg13cmos5l_a22oi_1
XFILLER_56_714 VDD VSS sg13cmos5l_decap_8
X_4087_ _4087_/Y _4087_/A _4087_/B VDD VSS sg13cmos5l_nor2_1
XFILLER_71_739 VDD VSS sg13cmos5l_decap_8
Xclkbuf_4_1_0_clk_i_regs clkload0/A clkbuf_0_clk_i_regs/X VDD VSS sg13cmos5l_buf_8
XFILLER_51_441 VDD VSS sg13cmos5l_decap_8
X_4989_ _4992_/A _5049_/S _4989_/B VDD VSS sg13cmos5l_xnor2_1
X_6728_ _7105_/B _6728_/A _7021_/A VDD VSS sg13cmos5l_nand2_1
X_6659_ _6661_/B _7701_/Q _6659_/B VDD VSS sg13cmos5l_xnor2_1
Xfanout340 _5244_/B1 _4688_/X VDD VSS sg13cmos5l_buf_1
Xfanout351 _4761_/A _4012_/A VDD VSS sg13cmos5l_buf_1
Xfanout362 _6223_/A _6227_/A VDD VSS sg13cmos5l_buf_1
Xfanout384 fanout384/X fanout385/X VDD VSS sg13cmos5l_buf_1
XFILLER_47_725 VDD VSS sg13cmos5l_decap_4
XFILLER_74_566 VDD VSS sg13cmos5l_decap_8
XFILLER_47_769 VDD VSS sg13cmos5l_decap_4
XFILLER_46_279 VDD VSS sg13cmos5l_decap_4
XFILLER_36_95 VDD VSS sg13cmos5l_decap_8
XFILLER_54_290 VDD VSS sg13cmos5l_decap_8
Xinput26 input26/X bank_A_wdata[25] VDD VSS sg13cmos5l_buf_1
Xinput37 input37/X bank_A_wdata[6] VDD VSS sg13cmos5l_buf_1
Xinput15 input15/X bank_A_wdata[15] VDD VSS sg13cmos5l_buf_1
Xinput48 _6205_/B bank_B_addr[6] VDD VSS sg13cmos5l_buf_1
Xinput59 input59/X bank_B_wdata[18] VDD VSS sg13cmos5l_buf_1
XFILLER_78_861 VDD VSS sg13cmos5l_decap_8
X_4010_ _4037_/B _4010_/A _4034_/A VDD VSS sg13cmos5l_xor2_1
XFILLER_38_725 VDD VSS sg13cmos5l_decap_8
X_5961_ _5961_/Y _5961_/A VDD VSS sg13cmos5l_inv_1
XFILLER_52_216 VDD VSS sg13cmos5l_fill_2
XFILLER_65_588 VDD VSS sg13cmos5l_decap_4
X_7700_ _7700_/Q clkload3/A _7700_/D fanout382/X VDD VSS sg13cmos5l_dfrbpq_1
X_4912_ _4975_/A _4847_/Y _4849_/A _4911_/Y VDD VSS sg13cmos5l_o21ai_1
XFILLER_80_569 VDD VSS sg13cmos5l_fill_1
X_7631_ _7632_/B _7608_/B _7631_/B VDD VSS sg13cmos5l_nand2b_2
X_5892_ _5967_/B _5892_/A _5882_/A VDD VSS sg13cmos5l_nor2b_1
XFILLER_61_772 VDD VSS sg13cmos5l_fill_1
X_4843_ _4844_/B _4843_/A _4850_/A VDD VSS sg13cmos5l_xnor2_1
XFILLER_60_271 VDD VSS sg13cmos5l_decap_4
X_7562_ _7565_/D _7562_/A _7618_/D _7618_/A _7562_/D VDD VSS sg13cmos5l_nand4_1
X_4774_ _4775_/B _4807_/A _4774_/B VDD VSS sg13cmos5l_xnor2_1
X_6513_ _6515_/A _6880_/B _6880_/A VDD VSS sg13cmos5l_nand2_2
X_7493_ _7626_/A _7493_/A _7493_/B VDD VSS sg13cmos5l_xor2_1
X_6444_ _6851_/A _7676_/Q _6444_/B VDD VSS sg13cmos5l_xnor2_1
X_6375_ _6814_/B _6375_/A _6375_/B VDD VSS sg13cmos5l_nand2_2
X_5326_ _5327_/B _5374_/A _5374_/B VDD VSS sg13cmos5l_xor2_1
X_5257_ _5257_/X _5257_/A VDD VSS sg13cmos5l_buf_1
X_4208_ _4209_/B _3963_/X _4313_/A _3937_/X _4314_/A VDD VSS sg13cmos5l_a22oi_1
XFILLER_57_28 VDD VSS sg13cmos5l_fill_2
X_5188_ _5189_/B _5493_/B1 _5568_/A _5430_/B1 _5569_/A VDD VSS sg13cmos5l_a22oi_1
X_4139_ _4140_/B _4139_/A _4139_/B VDD VSS sg13cmos5l_nand2_1
XFILLER_56_555 VDD VSS sg13cmos5l_decap_8
XFILLER_73_27 VDD VSS sg13cmos5l_decap_4
XFILLER_43_216 VDD VSS sg13cmos5l_decap_8
XFILLER_71_558 VDD VSS sg13cmos5l_fill_2
XFILLER_52_783 VDD VSS sg13cmos5l_fill_2
XFILLER_79_614 VDD VSS sg13cmos5l_decap_8
Xfanout192 _7294_/B _7248_/X VDD VSS sg13cmos5l_buf_1
Xfanout181 _7472_/B1 _7399_/Y VDD VSS sg13cmos5l_buf_1
XFILLER_47_555 VDD VSS sg13cmos5l_decap_4
XFILLER_75_875 VDD VSS sg13cmos5l_decap_4
XFILLER_62_503 VDD VSS sg13cmos5l_decap_8
XFILLER_62_536 VDD VSS sg13cmos5l_fill_1
XFILLER_97_7 VDD VSS sg13cmos5l_decap_8
X_4490_ _4505_/A _5044_/A _4489_/B _4489_/Y VDD VSS sg13cmos5l_o21ai_1
X_6160_ _6160_/Y _6138_/B _6160_/B VDD VSS sg13cmos5l_nand2b_1
XFILLER_69_135 VDD VSS sg13cmos5l_decap_4
X_5111_ _5228_/A _5111_/A _5111_/B VDD VSS sg13cmos5l_nand2_1
X_6091_ _6092_/A _6124_/B _6124_/A VDD VSS sg13cmos5l_xor2_1
XFILLER_69_179 VDD VSS sg13cmos5l_decap_8
X_5042_ _5043_/B _5042_/A _5042_/B VDD VSS sg13cmos5l_nand2_1
XFILLER_77_190 VDD VSS sg13cmos5l_decap_8
XFILLER_38_599 VDD VSS sg13cmos5l_fill_2
XFILLER_81_845 VDD VSS sg13cmos5l_fill_2
XFILLER_80_311 VDD VSS sg13cmos5l_decap_8
X_6993_ _7067_/A _7030_/B VDD VSS sg13cmos5l_buf_2
X_5944_ _5989_/A _5944_/A _5944_/B VDD VSS sg13cmos5l_xnor2_1
XFILLER_80_388 VDD VSS sg13cmos5l_decap_8
X_5875_ _5878_/A _5907_/A VDD VSS sg13cmos5l_inv_1
X_7614_ _7615_/C _7614_/A _7614_/B VDD VSS sg13cmos5l_and2_1
X_4826_ _4827_/B _5014_/A _4947_/B _4826_/C VDD VSS sg13cmos5l_nor3_1
X_7545_ _7546_/D _7615_/B _7615_/D _7545_/C _7615_/A VDD VSS sg13cmos5l_nor4_1
Xrebuffer715 rebuffer715/X rebuffer716/X VDD VSS sg13cmos5l_buf_1
Xrebuffer704 rebuffer704/X rebuffer705/X VDD VSS sg13cmos5l_buf_1
Xrebuffer726 rebuffer726/X _7337_/A VDD VSS sg13cmos5l_buf_1
Xrebuffer737 rebuffer737/X rebuffer738/X VDD VSS sg13cmos5l_buf_1
Xrebuffer748 rebuffer748/X rebuffer749/X VDD VSS sg13cmos5l_buf_1
X_4757_ _4758_/B _4803_/A _4803_/B VDD VSS sg13cmos5l_xor2_1
X_4688_ _4688_/X _4688_/A VDD VSS sg13cmos5l_buf_1
X_7476_ _7603_/B _7284_/Y _6785_/X _7399_/A VDD VSS sg13cmos5l_a21oi_1
Xrebuffer759 _7579_/B _7418_/A VDD VSS sg13cmos5l_buf_1
X_6427_ _6428_/A _6565_/B _6576_/A VDD VSS sg13cmos5l_nor2_1
X_6358_ _6368_/C _6621_/A _6645_/B VDD VSS sg13cmos5l_nand2_1
X_5309_ _5309_/X _5309_/A VDD VSS sg13cmos5l_buf_1
XFILLER_76_606 VDD VSS sg13cmos5l_fill_1
X_6289_ _6343_/A _6576_/A VDD VSS sg13cmos5l_inv_1
XFILLER_84_15 VDD VSS sg13cmos5l_decap_8
XFILLER_56_341 VDD VSS sg13cmos5l_fill_1
Xbank_B_sram.gen_ihp_256x32.u_sram_256x32_601 bank_B_sram.gen_ihp_256x32.u_sram_256x32_601/L_HI
+ VDD VSS sg13cmos5l_tiehi
XFILLER_72_856 VDD VSS sg13cmos5l_decap_8
XFILLER_71_333 VDD VSS sg13cmos5l_decap_8
Xbank_B_sram.gen_ihp_256x32.u_sram_256x32_612 bank_B_sram.gen_ihp_256x32.u_sram_256x32_612/L_HI
+ VDD VSS sg13cmos5l_tiehi
XFILLER_56_396 VDD VSS sg13cmos5l_decap_4
XFILLER_72_878 VDD VSS sg13cmos5l_decap_4
XFILLER_44_558 VDD VSS sg13cmos5l_decap_4
XFILLER_79_411 VDD VSS sg13cmos5l_fill_2
XFILLER_66_127 VDD VSS sg13cmos5l_decap_8
XFILLER_82_609 VDD VSS sg13cmos5l_decap_4
XFILLER_48_831 VDD VSS sg13cmos5l_fill_2
XFILLER_58_93 VDD VSS sg13cmos5l_decap_8
XFILLER_66_149 VDD VSS sg13cmos5l_decap_4
XFILLER_47_363 VDD VSS sg13cmos5l_decap_4
XFILLER_48_875 VDD VSS sg13cmos5l_fill_1
XFILLER_74_182 VDD VSS sg13cmos5l_fill_1
XFILLER_74_70 VDD VSS sg13cmos5l_fill_2
XFILLER_35_525 VDD VSS sg13cmos5l_decap_8
XFILLER_63_845 VDD VSS sg13cmos5l_fill_2
X_3990_ _4043_/A quant_cfg[5] VDD VSS sg13cmos5l_buf_1
XFILLER_74_81 VDD VSS sg13cmos5l_decap_8
XFILLER_62_399 VDD VSS sg13cmos5l_fill_1
X_5660_ _5660_/Y _5660_/A _5599_/B VDD VSS sg13cmos5l_nor2b_1
X_4611_ _4611_/Y _4611_/A VDD VSS sg13cmos5l_inv_1
X_5591_ _5592_/B _5650_/A _5650_/B VDD VSS sg13cmos5l_xor2_1
X_7330_ _7548_/A _7352_/A _7336_/A VDD VSS sg13cmos5l_xnor2_1
X_4542_ _4551_/A _4542_/A _4552_/A VDD VSS sg13cmos5l_xnor2_1
X_7261_ _7296_/A _7261_/A VDD VSS sg13cmos5l_buf_1
X_4473_ _4479_/C _4473_/A _4473_/B VDD VSS sg13cmos5l_nand2_1
X_6212_ _6212_/X _6212_/A VDD VSS sg13cmos5l_buf_1
X_7192_ _7192_/Y _7191_/B _7070_/Y _7191_/Y VDD VSS sg13cmos5l_o21ai_1
X_6143_ _6147_/A _6143_/A _6143_/B VDD VSS sg13cmos5l_xor2_1
X_6074_ _6103_/A _6160_/B _6041_/B _6073_/Y VDD VSS sg13cmos5l_o21ai_1
XFILLER_58_639 VDD VSS sg13cmos5l_decap_8
XFILLER_58_628 VDD VSS sg13cmos5l_fill_2
XFILLER_73_609 VDD VSS sg13cmos5l_decap_8
XFILLER_39_831 VDD VSS sg13cmos5l_fill_1
X_5025_ _5025_/Y _5025_/A VDD VSS sg13cmos5l_inv_1
XFILLER_54_801 VDD VSS sg13cmos5l_fill_1
XFILLER_81_631 VDD VSS sg13cmos5l_decap_8
X_6976_ _6979_/A _6975_/Y _6976_/B VDD VSS sg13cmos5l_nand2b_1
XFILLER_80_185 VDD VSS sg13cmos5l_decap_8
X_5927_ _5931_/B _6042_/A _5927_/B VDD VSS sg13cmos5l_xnor2_1
XFILLER_53_399 VDD VSS sg13cmos5l_decap_4
X_5858_ _6136_/A _5858_/A VDD VSS sg13cmos5l_buf_1
X_4809_ _4810_/B _5117_/B1 _4996_/A _5050_/B1 _4997_/A VDD VSS sg13cmos5l_a22oi_1
X_5789_ _5789_/Y _5789_/A _5751_/A VDD VSS sg13cmos5l_nor2b_1
X_7528_ _7616_/C _7554_/B _7554_/A VDD VSS sg13cmos5l_xor2_1
X_7459_ _7460_/B _7234_/Y _6785_/X _7399_/A VDD VSS sg13cmos5l_a21o_1
Xbank_A_sram.gen_ihp_256x32.u_sram_256x32_405 bank_A_sram.gen_ihp_256x32.u_sram_256x32_405/L_LO
+ VDD VSS sg13cmos5l_tielo
Xbank_A_sram.gen_ihp_256x32.u_sram_256x32_416 bank_A_sram.gen_ihp_256x32.u_sram_256x32_416/L_LO
+ VDD VSS sg13cmos5l_tielo
Xbank_A_sram.gen_ihp_256x32.u_sram_256x32_438 bank_A_sram.gen_ihp_256x32.u_sram_256x32_438/L_LO
+ VDD VSS sg13cmos5l_tielo
Xbank_A_sram.gen_ihp_256x32.u_sram_256x32_449 bank_A_sram.gen_ihp_256x32.u_sram_256x32_449/L_LO
+ VDD VSS sg13cmos5l_tielo
Xbank_A_sram.gen_ihp_256x32.u_sram_256x32_427 bank_A_sram.gen_ihp_256x32.u_sram_256x32_427/L_LO
+ VDD VSS sg13cmos5l_tielo
XFILLER_63_108 VDD VSS sg13cmos5l_fill_2
XFILLER_45_889 VDD VSS sg13cmos5l_fill_2
XFILLER_56_193 VDD VSS sg13cmos5l_fill_2
Xbank_B_sram.gen_ihp_256x32.u_sram_256x32_475 bank_B_sram.gen_ihp_256x32.u_sram_256x32_475/L_LO
+ VDD VSS sg13cmos5l_tielo
Xbank_B_sram.gen_ihp_256x32.u_sram_256x32_486 bank_B_sram.gen_ihp_256x32.u_sram_256x32_486/L_LO
+ VDD VSS sg13cmos5l_tielo
XFILLER_44_377 VDD VSS sg13cmos5l_fill_2
Xbank_B_sram.gen_ihp_256x32.u_sram_256x32_497 bank_B_sram.gen_ihp_256x32.u_sram_256x32_497/L_LO
+ VDD VSS sg13cmos5l_tielo
XFILLER_60_61 VDD VSS sg13cmos5l_fill_2
XFILLER_79_296 VDD VSS sg13cmos5l_decap_8
XFILLER_39_127 VDD VSS sg13cmos5l_decap_8
XFILLER_82_406 VDD VSS sg13cmos5l_decap_4
XFILLER_36_823 VDD VSS sg13cmos5l_fill_1
XFILLER_35_344 VDD VSS sg13cmos5l_decap_8
XFILLER_51_815 VDD VSS sg13cmos5l_fill_2
X_6830_ _6831_/A _6825_/Y _6996_/A _6829_/Y VDD VSS sg13cmos5l_a21oi_1
Xclkbuf_4_6_0_clk_i_regs clkload3/A clkbuf_0_clk_i_regs/X VDD VSS sg13cmos5l_buf_8
X_6761_ _6761_/Y _7002_/A _7021_/A VDD VSS sg13cmos5l_nand2_1
XFILLER_50_303 VDD VSS sg13cmos5l_decap_4
X_3973_ _4155_/A _3973_/A VDD VSS sg13cmos5l_buf_8
X_5712_ _5712_/X _5712_/A VDD VSS sg13cmos5l_buf_1
X_6692_ _6716_/A _7705_/Q _6692_/B VDD VSS sg13cmos5l_xnor2_1
X_5643_ _5643_/X _5643_/A VDD VSS sg13cmos5l_buf_1
X_5574_ _5626_/A _5870_/A _5574_/B VDD VSS sg13cmos5l_xnor2_1
X_4525_ _4526_/B _4525_/A _4647_/B _4525_/C VDD VSS sg13cmos5l_nor3_1
X_7313_ _7313_/X _7313_/A VDD VSS sg13cmos5l_buf_1
X_7244_ _7531_/B _7244_/A _7292_/A VDD VSS sg13cmos5l_nand2_1
Xrebuffer1200 _4192_/A _4187_/A VDD VSS sg13cmos5l_buf_1
X_4456_ _4456_/Y _4456_/A VDD VSS sg13cmos5l_inv_1
X_4387_ _4387_/X _4387_/A VDD VSS sg13cmos5l_buf_1
X_7175_ _7177_/B _7719_/Q _7175_/B VDD VSS sg13cmos5l_xnor2_1
Xrebuffer1244 rebuffer1244/X rebuffer1245/X VDD VSS sg13cmos5l_buf_1
Xrebuffer1233 _5673_/A1 _5674_/A VDD VSS sg13cmos5l_buf_1
Xrebuffer1211 rebuffer1211/X rebuffer1212/X VDD VSS sg13cmos5l_buf_1
Xrebuffer1222 rebuffer1222/X rebuffer1223/X VDD VSS sg13cmos5l_buf_1
X_6126_ _6152_/A _6135_/B _6135_/A VDD VSS sg13cmos5l_xor2_1
XFILLER_59_926 VDD VSS sg13cmos5l_decap_8
X_6057_ _6062_/A _6057_/A _6057_/B VDD VSS sg13cmos5l_nor2_1
X_5008_ _5058_/A _4953_/B _4953_/A _5007_/Y VDD VSS sg13cmos5l_a21oi_1
XFILLER_81_450 VDD VSS sg13cmos5l_decap_8
XFILLER_38_193 VDD VSS sg13cmos5l_decap_8
XFILLER_53_130 VDD VSS sg13cmos5l_decap_8
XFILLER_54_697 VDD VSS sg13cmos5l_decap_4
X_6959_ _6959_/Y _6956_/Y _6747_/X _6958_/Y VDD VSS sg13cmos5l_a21oi_1
XFILLER_76_244 VDD VSS sg13cmos5l_decap_8
XFILLER_55_50 VDD VSS sg13cmos5l_fill_2
XFILLER_55_83 VDD VSS sg13cmos5l_fill_2
XFILLER_71_60 VDD VSS sg13cmos5l_fill_2
X_4310_ _4310_/X _4310_/A VDD VSS sg13cmos5l_buf_1
X_5290_ _5303_/A _5290_/A _5290_/B VDD VSS sg13cmos5l_xor2_1
X_4241_ _4242_/B _4241_/A _4188_/X VDD VSS sg13cmos5l_nor2b_2
XFILLER_68_723 VDD VSS sg13cmos5l_decap_8
X_4172_ _4173_/B _4172_/A _4172_/B _4172_/C VDD VSS sg13cmos5l_nor3_1
XFILLER_67_211 VDD VSS sg13cmos5l_decap_8
XFILLER_67_299 VDD VSS sg13cmos5l_fill_1
XFILLER_36_620 VDD VSS sg13cmos5l_decap_4
XFILLER_82_269 VDD VSS sg13cmos5l_fill_1
XFILLER_35_152 VDD VSS sg13cmos5l_fill_1
XFILLER_51_612 VDD VSS sg13cmos5l_fill_2
XFILLER_63_461 VDD VSS sg13cmos5l_fill_2
X_6813_ _7018_/A _6811_/Y _6960_/A _6813_/S VDD VSS sg13cmos5l_mux2_1
X_3956_ _3956_/X _4086_/B VDD VSS sg13cmos5l_buf_1
X_6744_ _6901_/B _6744_/A _6744_/B VDD VSS sg13cmos5l_xnor2_1
X_6675_ _6677_/B _6675_/A _6678_/B VDD VSS sg13cmos5l_nor2b_1
X_5626_ _5626_/X _5626_/A _5626_/B VDD VSS sg13cmos5l_and2_1
X_5557_ _5621_/S _5622_/B1 _5309_/X _5557_/B1 _5683_/A VDD VSS sg13cmos5l_a22oi_1
X_5488_ _7689_/D _5488_/A _5488_/B VDD VSS sg13cmos5l_xnor2_1
X_4508_ _4749_/A _4508_/A VDD VSS sg13cmos5l_buf_1
XFILLER_116_23 VDD VSS sg13cmos5l_decap_4
XFILLER_78_509 VDD VSS sg13cmos5l_fill_2
X_7227_ _7227_/Y _7265_/A _7226_/Y _7059_/A VDD VSS sg13cmos5l_o21ai_1
X_4439_ _4455_/A _4439_/A _4439_/B VDD VSS sg13cmos5l_xor2_1
XFILLER_59_723 VDD VSS sg13cmos5l_decap_8
XFILLER_59_712 VDD VSS sg13cmos5l_fill_1
X_7158_ _7158_/X _7158_/A VDD VSS sg13cmos5l_buf_1
XFILLER_58_211 VDD VSS sg13cmos5l_decap_8
XFILLER_58_222 VDD VSS sg13cmos5l_fill_2
X_6109_ _6144_/A _6109_/A _6108_/Y VDD VSS sg13cmos5l_nor2b_1
X_7089_ _7089_/Y _7108_/S _7187_/B VDD VSS sg13cmos5l_nor2_1
XFILLER_74_726 VDD VSS sg13cmos5l_decap_4
XFILLER_46_417 VDD VSS sg13cmos5l_decap_4
XFILLER_46_439 VDD VSS sg13cmos5l_decap_8
XFILLER_39_491 VDD VSS sg13cmos5l_decap_8
XFILLER_70_932 VDD VSS sg13cmos5l_fill_2
XFILLER_42_623 VDD VSS sg13cmos5l_fill_2
XFILLER_42_634 VDD VSS sg13cmos5l_fill_1
XFILLER_42_645 VDD VSS sg13cmos5l_decap_4
XFILLER_41_122 VDD VSS sg13cmos5l_fill_1
XFILLER_77_531 VDD VSS sg13cmos5l_decap_8
XFILLER_49_244 VDD VSS sg13cmos5l_fill_2
XFILLER_64_225 VDD VSS sg13cmos5l_fill_2
XFILLER_65_726 VDD VSS sg13cmos5l_decap_4
XFILLER_80_707 VDD VSS sg13cmos5l_fill_2
XFILLER_61_932 VDD VSS sg13cmos5l_fill_2
X_4790_ _4844_/A _4790_/A _4784_/A VDD VSS sg13cmos5l_nor2b_1
XANTENNA_29 _7712_/D VDD VSS sg13cmos5l_antennanp
XANTENNA_18 output156/A VDD VSS sg13cmos5l_antennanp
X_6460_ _6462_/A _6461_/A _6527_/A _7678_/Q VDD VSS sg13cmos5l_a21oi_1
X_6391_ _6391_/X _6391_/A VDD VSS sg13cmos5l_buf_4
X_5411_ _5477_/B _5411_/A _5424_/B VDD VSS sg13cmos5l_xnor2_1
Xoutput114 act_out[6] _6226_/Y VDD VSS sg13cmos5l_buf_1
Xoutput125 bank_A_rdata[18] _4699_/A VDD VSS sg13cmos5l_buf_1
X_5342_ _5343_/B _5378_/A _5342_/B VDD VSS sg13cmos5l_xnor2_1
Xoutput136 bank_A_rdata[28] _5332_/A VDD VSS sg13cmos5l_buf_1
Xoutput147 bank_A_rdata[9] _4169_/A VDD VSS sg13cmos5l_buf_1
Xoutput158 bank_B_rdata[19] output158/A VDD VSS sg13cmos5l_buf_1
X_5273_ _5276_/A _5517_/A _5633_/A _5519_/B VDD VSS sg13cmos5l_a21oi_1
Xoutput169 bank_B_rdata[29] output169/A VDD VSS sg13cmos5l_buf_1
X_7012_ _7012_/Y _7012_/A _7071_/B VDD VSS sg13cmos5l_nand2_1
X_4224_ _4225_/B _4269_/A _4269_/B VDD VSS sg13cmos5l_xor2_1
X_4155_ _4155_/X _4155_/A VDD VSS sg13cmos5l_buf_1
XFILLER_68_575 VDD VSS sg13cmos5l_fill_1
XFILLER_68_553 VDD VSS sg13cmos5l_decap_8
X_4086_ _4087_/B _4128_/A _4086_/B _4086_/C VDD VSS sg13cmos5l_nor3_2
XFILLER_102_25 VDD VSS sg13cmos5l_decap_4
XFILLER_43_409 VDD VSS sg13cmos5l_decap_4
XFILLER_70_239 VDD VSS sg13cmos5l_decap_8
XFILLER_51_464 VDD VSS sg13cmos5l_decap_8
X_4988_ _4989_/B _5245_/A _4988_/B VDD VSS sg13cmos5l_xnor2_1
X_3939_ _4172_/A quant_cfg[1] VDD VSS sg13cmos5l_buf_1
X_6727_ _7034_/B _6972_/B VDD VSS sg13cmos5l_buf_2
X_6658_ _6659_/B _6655_/Y _6665_/B _6684_/C VDD VSS sg13cmos5l_o21ai_1
X_5609_ _5670_/A _5609_/A _5609_/B VDD VSS sg13cmos5l_and2_1
X_6589_ _6649_/A _6589_/A VDD VSS sg13cmos5l_buf_4
XFILLER_87_15 VDD VSS sg13cmos5l_decap_8
XFILLER_79_807 VDD VSS sg13cmos5l_fill_2
XFILLER_78_339 VDD VSS sg13cmos5l_decap_8
Xfanout341 _5178_/B1 _4631_/X VDD VSS sg13cmos5l_buf_1
Xfanout330 _5630_/A _5321_/A VDD VSS sg13cmos5l_buf_1
Xfanout352 _3964_/C _3963_/X VDD VSS sg13cmos5l_buf_4
Xfanout363 _6209_/A1 _6185_/X VDD VSS sg13cmos5l_buf_1
XFILLER_74_512 VDD VSS sg13cmos5l_fill_2
Xfanout385 fanout385/X fanout386/X VDD VSS sg13cmos5l_buf_1
XFILLER_46_258 VDD VSS sg13cmos5l_decap_8
XFILLER_36_74 VDD VSS sg13cmos5l_decap_8
XFILLER_70_773 VDD VSS sg13cmos5l_decap_8
XFILLER_70_784 VDD VSS sg13cmos5l_fill_1
Xinput27 input27/X bank_A_wdata[26] VDD VSS sg13cmos5l_buf_1
Xinput16 input16/X bank_A_wdata[16] VDD VSS sg13cmos5l_buf_1
Xinput49 _6208_/B bank_B_addr[7] VDD VSS sg13cmos5l_buf_1
Xinput38 input38/X bank_A_wdata[7] VDD VSS sg13cmos5l_buf_1
XFILLER_69_317 VDD VSS sg13cmos5l_fill_1
XFILLER_69_328 VDD VSS sg13cmos5l_fill_1
XFILLER_77_361 VDD VSS sg13cmos5l_decap_8
XFILLER_38_748 VDD VSS sg13cmos5l_decap_8
XFILLER_38_715 VDD VSS sg13cmos5l_fill_1
XFILLER_37_214 VDD VSS sg13cmos5l_decap_8
XFILLER_65_512 VDD VSS sg13cmos5l_decap_8
XFILLER_38_759 VDD VSS sg13cmos5l_fill_2
XFILLER_37_236 VDD VSS sg13cmos5l_fill_2
XFILLER_37_225 VDD VSS sg13cmos5l_fill_2
XFILLER_80_504 VDD VSS sg13cmos5l_decap_8
X_5960_ _5964_/A _5960_/A _5998_/A VDD VSS sg13cmos5l_xnor2_1
XFILLER_65_567 VDD VSS sg13cmos5l_fill_1
X_5891_ _5892_/A _5891_/A VDD VSS sg13cmos5l_inv_1
X_4911_ _4911_/Y _4844_/A _4846_/Y _4844_/B VDD VSS sg13cmos5l_o21ai_1
X_7630_ _7631_/B _7630_/A _7489_/Y VDD VSS sg13cmos5l_nor2b_2
X_4842_ _4850_/A _4852_/A _4851_/A VDD VSS sg13cmos5l_xnor2_1
X_7561_ _7562_/A _7561_/A _7561_/B _7561_/C VDD VSS sg13cmos5l_nor3_2
X_4773_ _4774_/B _4773_/A _4773_/B VDD VSS sg13cmos5l_xor2_1
X_6512_ _6880_/A _7684_/Q _6512_/B VDD VSS sg13cmos5l_xnor2_1
X_7492_ _7493_/B _7492_/A _7492_/B VDD VSS sg13cmos5l_nand2_1
X_6443_ _6444_/B _6457_/A _6442_/Y _6461_/C VDD VSS sg13cmos5l_o21ai_1
X_6374_ _6375_/A _6815_/B _6815_/A VDD VSS sg13cmos5l_nand2_2
X_5325_ _5374_/B _5446_/A _5325_/B VDD VSS sg13cmos5l_xnor2_1
X_5256_ _5265_/A _5321_/A _5256_/B VDD VSS sg13cmos5l_xnor2_1
X_4207_ _4210_/A _4207_/A _4207_/B VDD VSS sg13cmos5l_xnor2_1
X_5187_ _5215_/A _5154_/B _5154_/A _5186_/Y VDD VSS sg13cmos5l_a21oi_1
X_4138_ _4140_/A _4138_/A _4138_/B VDD VSS sg13cmos5l_nand2_2
X_4069_ _4099_/A _4108_/C _4108_/B _4109_/B VDD VSS sg13cmos5l_a21oi_1
XFILLER_36_291 VDD VSS sg13cmos5l_decap_8
XFILLER_52_740 VDD VSS sg13cmos5l_fill_1
XFILLER_40_924 VDD VSS sg13cmos5l_decap_8
XFILLER_51_261 VDD VSS sg13cmos5l_decap_8
XFILLER_51_272 VDD VSS sg13cmos5l_fill_1
XFILLER_52_773 VDD VSS sg13cmos5l_fill_1
XFILLER_51_283 VDD VSS sg13cmos5l_decap_4
XFILLER_98_25 VDD VSS sg13cmos5l_decap_4
XFILLER_78_158 VDD VSS sg13cmos5l_fill_2
XFILLER_78_136 VDD VSS sg13cmos5l_fill_1
Xfanout182 _6684_/C _6802_/B VDD VSS sg13cmos5l_buf_1
XFILLER_47_40 VDD VSS sg13cmos5l_decap_4
XFILLER_47_501 VDD VSS sg13cmos5l_decap_8
XFILLER_59_350 VDD VSS sg13cmos5l_decap_4
Xfanout193 _7191_/B _7184_/B VDD VSS sg13cmos5l_buf_1
XFILLER_35_707 VDD VSS sg13cmos5l_fill_1
XFILLER_63_61 VDD VSS sg13cmos5l_decap_8
XFILLER_70_592 VDD VSS sg13cmos5l_fill_1
XFILLER_8_12 VDD VSS sg13cmos5l_decap_8
XFILLER_69_114 VDD VSS sg13cmos5l_fill_1
X_5110_ _5111_/B _5110_/A _5110_/B VDD VSS sg13cmos5l_nand2_1
X_6090_ _6124_/A _6120_/A _6090_/B VDD VSS sg13cmos5l_xnor2_1
X_5041_ _5043_/A _5041_/A _5041_/B VDD VSS sg13cmos5l_nand2_1
XFILLER_66_887 VDD VSS sg13cmos5l_decap_4
XFILLER_65_364 VDD VSS sg13cmos5l_fill_1
X_6992_ _6994_/A _6992_/A VDD VSS sg13cmos5l_inv_2
XFILLER_53_526 VDD VSS sg13cmos5l_decap_4
XFILLER_81_868 VDD VSS sg13cmos5l_fill_2
XFILLER_80_367 VDD VSS sg13cmos5l_decap_8
X_5943_ _5944_/B _6136_/B _5943_/A2 _6114_/B _5943_/B2 VDD VSS sg13cmos5l_a22oi_1
X_5874_ _5907_/A _5874_/A _5874_/B VDD VSS sg13cmos5l_xor2_1
XFILLER_61_570 VDD VSS sg13cmos5l_decap_8
X_7613_ _7617_/B _7613_/A _7613_/B _7613_/C VDD VSS sg13cmos5l_nor3_1
X_4825_ _4826_/C _5190_/A VDD VSS sg13cmos5l_inv_1
XFILLER_61_592 VDD VSS sg13cmos5l_fill_2
X_7544_ _7615_/A _7544_/A _7544_/B VDD VSS sg13cmos5l_xor2_1
Xrebuffer705 rebuffer705/X rebuffer706/X VDD VSS sg13cmos5l_buf_1
Xrebuffer727 _7504_/A1 _7381_/A VDD VSS sg13cmos5l_buf_1
Xrebuffer716 rebuffer716/X rebuffer717/X VDD VSS sg13cmos5l_buf_1
Xrebuffer749 rebuffer749/X rebuffer750/X VDD VSS sg13cmos5l_buf_1
Xrebuffer738 rebuffer738/X rebuffer739/X VDD VSS sg13cmos5l_buf_1
X_4756_ _4803_/B _4875_/A _4756_/B VDD VSS sg13cmos5l_xnor2_1
X_7475_ _7605_/A _7475_/A _7475_/B VDD VSS sg13cmos5l_nand2_2
X_4687_ _4694_/A _4749_/A _4687_/B VDD VSS sg13cmos5l_xnor2_1
X_6426_ _6436_/A _6821_/A _6820_/A _6821_/B VDD VSS sg13cmos5l_nand3_1
X_6357_ _6645_/B _6982_/A _6507_/A VDD VSS sg13cmos5l_nor2_1
XFILLER_68_28 VDD VSS sg13cmos5l_fill_2
X_5308_ _5317_/A _5044_/A _5307_/A _5307_/Y VDD VSS sg13cmos5l_a21oi_1
X_6288_ _6299_/B _6288_/A _6288_/B VDD VSS sg13cmos5l_nand2_2
XFILLER_75_117 VDD VSS sg13cmos5l_decap_8
X_5239_ _5303_/B _5239_/A _5239_/B VDD VSS sg13cmos5l_nand2_1
XFILLER_57_810 VDD VSS sg13cmos5l_decap_8
XFILLER_57_821 VDD VSS sg13cmos5l_fill_1
XFILLER_75_139 VDD VSS sg13cmos5l_decap_8
Xbank_B_sram.gen_ihp_256x32.u_sram_256x32_613 bank_B_sram.gen_ihp_256x32.u_sram_256x32_613/L_HI
+ VDD VSS sg13cmos5l_tiehi
Xbank_B_sram.gen_ihp_256x32.u_sram_256x32_602 bank_B_sram.gen_ihp_256x32.u_sram_256x32_602/L_HI
+ VDD VSS sg13cmos5l_tiehi
XFILLER_71_389 VDD VSS sg13cmos5l_decap_8
XFILLER_71_378 VDD VSS sg13cmos5l_decap_4
XFILLER_40_765 VDD VSS sg13cmos5l_fill_2
XFILLER_67_618 VDD VSS sg13cmos5l_fill_2
XFILLER_58_61 VDD VSS sg13cmos5l_fill_2
XFILLER_12_8 VDD VSS sg13cmos5l_fill_2
XFILLER_48_843 VDD VSS sg13cmos5l_decap_8
XFILLER_48_898 VDD VSS sg13cmos5l_fill_1
XFILLER_63_835 VDD VSS sg13cmos5l_fill_1
XFILLER_50_507 VDD VSS sg13cmos5l_decap_8
XFILLER_62_367 VDD VSS sg13cmos5l_fill_2
XFILLER_50_529 VDD VSS sg13cmos5l_decap_4
XFILLER_88_4 VDD VSS sg13cmos5l_decap_8
X_4610_ _4613_/A _4668_/B _4668_/A VDD VSS sg13cmos5l_xor2_1
X_5590_ _5650_/B _5590_/A _5590_/B VDD VSS sg13cmos5l_xnor2_1
X_4541_ _4552_/A _4553_/B _4553_/A VDD VSS sg13cmos5l_xor2_1
X_7260_ _7272_/A _7260_/A _7542_/B VDD VSS sg13cmos5l_nand2_2
X_4472_ _4547_/B _4545_/A _4469_/Y _4473_/A VDD VSS sg13cmos5l_a21o_1
X_6211_ _6211_/Y _6211_/A VDD VSS sg13cmos5l_inv_1
X_7191_ _7191_/Y _7191_/A _7191_/B VDD VSS sg13cmos5l_nand2_1
X_6142_ _6143_/B _6119_/B _6142_/B VDD VSS sg13cmos5l_nand2b_1
X_6073_ _6073_/Y _6073_/A _6073_/B VDD VSS sg13cmos5l_nand2_1
XFILLER_38_320 VDD VSS sg13cmos5l_fill_1
X_5024_ _5096_/B _5091_/A _5024_/B VDD VSS sg13cmos5l_xnor2_1
XFILLER_39_887 VDD VSS sg13cmos5l_decap_8
XFILLER_38_364 VDD VSS sg13cmos5l_decap_8
XFILLER_81_610 VDD VSS sg13cmos5l_decap_8
XFILLER_53_323 VDD VSS sg13cmos5l_fill_2
XFILLER_53_301 VDD VSS sg13cmos5l_decap_4
XFILLER_65_161 VDD VSS sg13cmos5l_fill_1
X_6975_ _6975_/Y _6711_/X _6798_/Y _6974_/Y VDD VSS sg13cmos5l_o21ai_1
XFILLER_54_857 VDD VSS sg13cmos5l_fill_1
XFILLER_65_194 VDD VSS sg13cmos5l_decap_8
XFILLER_110_25 VDD VSS sg13cmos5l_decap_4
XFILLER_81_687 VDD VSS sg13cmos5l_fill_2
XFILLER_80_164 VDD VSS sg13cmos5l_decap_8
X_5926_ _5927_/B _5967_/B _5967_/A VDD VSS sg13cmos5l_xnor2_1
XFILLER_53_378 VDD VSS sg13cmos5l_decap_8
XFILLER_70_18 VDD VSS sg13cmos5l_decap_8
X_5857_ _5866_/A _5796_/B _5415_/A _5857_/S VDD VSS sg13cmos5l_mux2_1
X_5788_ _6168_/A _5788_/A VDD VSS sg13cmos5l_buf_1
X_4808_ _4835_/A _4775_/B _4775_/A _4807_/Y VDD VSS sg13cmos5l_a21oi_1
X_7527_ _7554_/A _7558_/B _7559_/A _7305_/Y VDD VSS sg13cmos5l_a21o_1
X_4739_ _4740_/B _4920_/B1 _5118_/A _4859_/B1 _5119_/A VDD VSS sg13cmos5l_a22oi_1
X_7458_ _7594_/A _7458_/A _7491_/A _7492_/B VDD VSS sg13cmos5l_nand3_1
X_6409_ _6409_/Y _6410_/B _6410_/A VDD VSS sg13cmos5l_nor2_1
X_7389_ _7393_/A _7389_/A _7509_/A VDD VSS sg13cmos5l_nand2_2
Xbank_A_sram.gen_ihp_256x32.u_sram_256x32_406 bank_A_sram.gen_ihp_256x32.u_sram_256x32_406/L_LO
+ VDD VSS sg13cmos5l_tielo
Xbank_A_sram.gen_ihp_256x32.u_sram_256x32_417 bank_A_sram.gen_ihp_256x32.u_sram_256x32_417/L_LO
+ VDD VSS sg13cmos5l_tielo
XFILLER_95_15 VDD VSS sg13cmos5l_decap_8
Xbank_A_sram.gen_ihp_256x32.u_sram_256x32_439 bank_A_sram.gen_ihp_256x32.u_sram_256x32_439/L_LO
+ VDD VSS sg13cmos5l_tielo
Xbank_A_sram.gen_ihp_256x32.u_sram_256x32_428 bank_A_sram.gen_ihp_256x32.u_sram_256x32_428/L_LO
+ VDD VSS sg13cmos5l_tielo
XFILLER_77_927 VDD VSS sg13cmos5l_decap_8
XFILLER_48_106 VDD VSS sg13cmos5l_decap_8
XFILLER_72_621 VDD VSS sg13cmos5l_fill_1
XFILLER_72_654 VDD VSS sg13cmos5l_decap_4
XFILLER_44_356 VDD VSS sg13cmos5l_fill_2
XFILLER_72_687 VDD VSS sg13cmos5l_fill_2
Xbank_B_sram.gen_ihp_256x32.u_sram_256x32_476 bank_B_sram.gen_ihp_256x32.u_sram_256x32_476/L_LO
+ VDD VSS sg13cmos5l_tielo
XFILLER_44_52 VDD VSS sg13cmos5l_fill_1
Xbank_B_sram.gen_ihp_256x32.u_sram_256x32_487 bank_B_sram.gen_ihp_256x32.u_sram_256x32_487/L_LO
+ VDD VSS sg13cmos5l_tielo
Xbank_B_sram.gen_ihp_256x32.u_sram_256x32_498 bank_B_sram.gen_ihp_256x32.u_sram_256x32_498/L_LO
+ VDD VSS sg13cmos5l_tielo
XFILLER_79_275 VDD VSS sg13cmos5l_decap_8
XFILLER_39_106 VDD VSS sg13cmos5l_decap_8
XFILLER_48_662 VDD VSS sg13cmos5l_fill_1
XFILLER_82_429 VDD VSS sg13cmos5l_decap_8
XFILLER_35_312 VDD VSS sg13cmos5l_decap_4
XFILLER_36_879 VDD VSS sg13cmos5l_decap_8
XFILLER_63_643 VDD VSS sg13cmos5l_decap_8
X_6760_ _7002_/A _6915_/B _6910_/S _6759_/X VDD VSS sg13cmos5l_a21oi_1
XFILLER_51_838 VDD VSS sg13cmos5l_fill_2
X_5711_ _5758_/A _5711_/A _5754_/B VDD VSS sg13cmos5l_nand2_1
X_3972_ _3977_/A _3972_/A _3972_/B VDD VSS sg13cmos5l_nor2_1
XFILLER_50_348 VDD VSS sg13cmos5l_fill_1
XFILLER_62_197 VDD VSS sg13cmos5l_decap_4
X_6691_ _6692_/B _6696_/A _6690_/Y _6684_/C VDD VSS sg13cmos5l_o21ai_1
X_5642_ _5647_/A _5810_/B _5642_/B VDD VSS sg13cmos5l_xnor2_1
X_5573_ _5574_/B _6026_/B1 _5869_/A2 _5985_/B1 _5869_/B2 VDD VSS sg13cmos5l_a22oi_1
X_4524_ _4525_/C _4872_/A VDD VSS sg13cmos5l_inv_1
X_7312_ _7312_/Y _7312_/A VDD VSS sg13cmos5l_inv_1
X_7243_ _7245_/B _7292_/A _7257_/A VDD VSS sg13cmos5l_xnor2_1
Xrebuffer1201 _4139_/B _4097_/B VDD VSS sg13cmos5l_buf_1
X_4455_ _4539_/B _4455_/A _4455_/B VDD VSS sg13cmos5l_xor2_1
X_4386_ _4750_/A _4386_/A VDD VSS sg13cmos5l_buf_1
X_7174_ _7175_/B _7159_/Y _7174_/B VDD VSS sg13cmos5l_nand2b_1
Xrebuffer1223 rebuffer1223/X rebuffer1224/X VDD VSS sg13cmos5l_buf_1
Xrebuffer1212 rebuffer1212/X rebuffer1213/X VDD VSS sg13cmos5l_buf_1
Xrebuffer1234 _4848_/B _4847_/Y VDD VSS sg13cmos5l_buf_1
Xrebuffer1245 rebuffer1245/X rebuffer1246/X VDD VSS sg13cmos5l_buf_1
X_6125_ _6135_/A _6123_/Y _6120_/A _6124_/Y VDD VSS sg13cmos5l_o21ai_1
XFILLER_58_415 VDD VSS sg13cmos5l_decap_8
XFILLER_105_25 VDD VSS sg13cmos5l_decap_4
X_6056_ _6063_/A _6029_/B _5788_/A _6056_/S VDD VSS sg13cmos5l_mux2_1
X_5007_ _5007_/Y _5007_/A _5007_/B VDD VSS sg13cmos5l_nor2_1
XFILLER_39_695 VDD VSS sg13cmos5l_fill_2
XFILLER_38_172 VDD VSS sg13cmos5l_decap_8
XFILLER_41_348 VDD VSS sg13cmos5l_decap_8
XFILLER_35_890 VDD VSS sg13cmos5l_decap_4
XFILLER_14_11 VDD VSS sg13cmos5l_decap_8
XFILLER_53_186 VDD VSS sg13cmos5l_fill_1
X_6958_ _6958_/Y _6964_/S _6958_/B VDD VSS sg13cmos5l_nor2_1
XFILLER_50_871 VDD VSS sg13cmos5l_decap_8
X_6889_ _6890_/A _6877_/Y _6937_/A _6888_/Y VDD VSS sg13cmos5l_a21oi_1
X_5909_ _5948_/S _5949_/B1 _6114_/A _5909_/B1 _6026_/B2 VDD VSS sg13cmos5l_a22oi_1
XFILLER_39_85 VDD VSS sg13cmos5l_decap_8
XFILLER_36_109 VDD VSS sg13cmos5l_decap_8
XFILLER_57_470 VDD VSS sg13cmos5l_fill_1
XFILLER_45_643 VDD VSS sg13cmos5l_fill_2
XFILLER_44_175 VDD VSS sg13cmos5l_fill_2
XFILLER_60_657 VDD VSS sg13cmos5l_fill_2
XFILLER_71_50 VDD VSS sg13cmos5l_decap_4
XFILLER_40_381 VDD VSS sg13cmos5l_fill_2
X_4240_ _4245_/B _4350_/A _4238_/Y _4239_/Y VDD VSS sg13cmos5l_o21ai_1
X_4171_ _4172_/C _4511_/A VDD VSS sg13cmos5l_inv_1
XFILLER_67_201 VDD VSS sg13cmos5l_fill_1
XFILLER_82_204 VDD VSS sg13cmos5l_decap_4
XFILLER_55_429 VDD VSS sg13cmos5l_decap_4
XFILLER_64_930 VDD VSS sg13cmos5l_decap_4
X_6812_ _6960_/A _6812_/A _6812_/B VDD VSS sg13cmos5l_xnor2_1
XFILLER_36_676 VDD VSS sg13cmos5l_decap_8
XFILLER_51_624 VDD VSS sg13cmos5l_decap_4
XFILLER_51_657 VDD VSS sg13cmos5l_decap_8
X_3955_ _4086_/B _3955_/A VDD VSS sg13cmos5l_inv_1
X_6743_ _6744_/B _6743_/A _6743_/B VDD VSS sg13cmos5l_nand2_1
XFILLER_51_668 VDD VSS sg13cmos5l_fill_2
X_6674_ _6678_/B _6674_/A _7703_/Q _6684_/C VDD VSS sg13cmos5l_nand3_1
X_5625_ _5628_/A _5682_/S _5625_/B VDD VSS sg13cmos5l_xnor2_1
X_5556_ _5564_/A _5496_/B _5302_/A _5556_/S VDD VSS sg13cmos5l_mux2_1
X_5487_ _5488_/B _5489_/A _5489_/B VDD VSS sg13cmos5l_nand2_1
X_4507_ _4537_/A _4455_/B _4455_/A _4506_/Y VDD VSS sg13cmos5l_a21oi_1
X_7226_ _7226_/Y _7226_/A _7234_/B VDD VSS sg13cmos5l_nand2_2
X_4438_ _4439_/B _4500_/A _4500_/B VDD VSS sg13cmos5l_xor2_1
X_7157_ _7157_/Y _7152_/Y _7205_/A _7156_/Y VDD VSS sg13cmos5l_a21oi_1
XFILLER_59_746 VDD VSS sg13cmos5l_fill_2
X_4369_ _4369_/X _4369_/A _4369_/B VDD VSS sg13cmos5l_and2_1
X_6108_ _6108_/Y _6088_/B _6108_/B VDD VSS sg13cmos5l_nand2b_1
X_7088_ _7187_/B _6958_/B _7087_/A _7087_/Y VDD VSS sg13cmos5l_a21oi_1
X_6039_ _6073_/B _6039_/A _6048_/A VDD VSS sg13cmos5l_xnor2_1
XFILLER_73_259 VDD VSS sg13cmos5l_decap_8
XFILLER_70_911 VDD VSS sg13cmos5l_fill_2
XFILLER_41_101 VDD VSS sg13cmos5l_decap_8
XFILLER_54_484 VDD VSS sg13cmos5l_decap_8
XFILLER_42_679 VDD VSS sg13cmos5l_fill_2
XFILLER_41_145 VDD VSS sg13cmos5l_decap_8
XFILLER_41_31 VDD VSS sg13cmos5l_fill_1
XFILLER_9_0 VDD VSS sg13cmos5l_fill_1
XFILLER_77_565 VDD VSS sg13cmos5l_decap_8
XFILLER_65_716 VDD VSS sg13cmos5l_decap_4
XFILLER_65_738 VDD VSS sg13cmos5l_fill_1
XFILLER_66_61 VDD VSS sg13cmos5l_fill_1
XFILLER_73_782 VDD VSS sg13cmos5l_decap_8
XFILLER_73_793 VDD VSS sg13cmos5l_fill_1
XFILLER_72_270 VDD VSS sg13cmos5l_decap_4
XFILLER_60_421 VDD VSS sg13cmos5l_decap_4
XFILLER_82_82 VDD VSS sg13cmos5l_fill_1
XANTENNA_19 _6203_/Y VDD VSS sg13cmos5l_antennanp
X_5410_ _5424_/B _5425_/B _5425_/A VDD VSS sg13cmos5l_xor2_1
X_6390_ _6401_/B _6400_/A VDD VSS sg13cmos5l_inv_1
Xoutput115 act_out[7] _6228_/Y VDD VSS sg13cmos5l_buf_1
X_5341_ _5342_/B _5341_/A _5341_/B VDD VSS sg13cmos5l_xor2_1
Xoutput137 bank_A_rdata[29] _5393_/A VDD VSS sg13cmos5l_buf_1
Xoutput126 bank_A_rdata[19] _4764_/A VDD VSS sg13cmos5l_buf_1
Xoutput148 bank_B_rdata[0] _6213_/B VDD VSS sg13cmos5l_buf_1
Xoutput159 bank_B_rdata[1] _6215_/B VDD VSS sg13cmos5l_buf_1
X_5272_ _5633_/A _5272_/A VDD VSS sg13cmos5l_buf_1
X_7011_ _7195_/B _7038_/B VDD VSS sg13cmos5l_buf_1
X_4223_ _4269_/B _4223_/A _4223_/B VDD VSS sg13cmos5l_xnor2_1
X_4154_ _4185_/A _5944_/A _4153_/B _4153_/Y VDD VSS sg13cmos5l_o21ai_1
X_4085_ _4086_/C _4375_/A VDD VSS sg13cmos5l_inv_1
XFILLER_71_708 VDD VSS sg13cmos5l_fill_1
XFILLER_70_207 VDD VSS sg13cmos5l_decap_4
XFILLER_36_462 VDD VSS sg13cmos5l_decap_8
XFILLER_36_440 VDD VSS sg13cmos5l_decap_8
XFILLER_55_259 VDD VSS sg13cmos5l_decap_8
X_6726_ _6728_/A _6726_/A VDD VSS sg13cmos5l_inv_1
X_4987_ _4988_/B _5178_/B1 _5118_/A _5117_/B1 _5119_/A VDD VSS sg13cmos5l_a22oi_1
X_3938_ _3953_/A _3972_/A _3965_/B VDD VSS sg13cmos5l_nand2_1
X_6657_ _6665_/B _6664_/A VDD VSS sg13cmos5l_inv_1
XFILLER_11_12 VDD VSS sg13cmos5l_fill_1
X_6588_ _6588_/Y _6588_/A _6587_/A VDD VSS sg13cmos5l_nor2b_1
X_5608_ _5609_/B _5608_/A _5608_/B _5608_/C VDD VSS sg13cmos5l_nand3_1
X_5539_ _5608_/B _5541_/B _5541_/A VDD VSS sg13cmos5l_nor2_1
XFILLER_78_318 VDD VSS sg13cmos5l_decap_8
Xfanout320 _6026_/B1 _5572_/X VDD VSS sg13cmos5l_buf_1
X_7209_ _7209_/Y _7280_/A1 _7362_/B _7208_/Y VDD VSS sg13cmos5l_o21ai_1
Xfanout331 _5781_/A _5418_/A VDD VSS sg13cmos5l_buf_1
XFILLER_59_521 VDD VSS sg13cmos5l_decap_8
Xfanout353 _4387_/A _3961_/X VDD VSS sg13cmos5l_buf_1
Xfanout375 _4854_/A _4487_/X VDD VSS sg13cmos5l_buf_1
Xfanout364 _5048_/A _4984_/A VDD VSS sg13cmos5l_buf_1
Xfanout342 _5117_/B1 _4574_/X VDD VSS sg13cmos5l_buf_1
Xfanout386 fanout386/X fanout392/X VDD VSS sg13cmos5l_buf_1
XFILLER_74_557 VDD VSS sg13cmos5l_fill_2
XFILLER_74_535 VDD VSS sg13cmos5l_decap_8
XFILLER_47_749 VDD VSS sg13cmos5l_fill_2
XFILLER_36_53 VDD VSS sg13cmos5l_decap_8
XFILLER_62_708 VDD VSS sg13cmos5l_fill_2
XFILLER_82_590 VDD VSS sg13cmos5l_fill_1
XFILLER_43_933 VDD VSS sg13cmos5l_fill_1
XFILLER_43_922 VDD VSS sg13cmos5l_decap_8
Xinput28 input28/X bank_A_wdata[27] VDD VSS sg13cmos5l_buf_1
Xinput17 input17/X bank_A_wdata[17] VDD VSS sg13cmos5l_buf_1
Xinput39 input39/X bank_A_wdata[8] VDD VSS sg13cmos5l_buf_1
XFILLER_42_8 VDD VSS sg13cmos5l_fill_1
XFILLER_78_885 VDD VSS sg13cmos5l_fill_1
XFILLER_37_248 VDD VSS sg13cmos5l_decap_8
XFILLER_65_546 VDD VSS sg13cmos5l_fill_1
XFILLER_53_708 VDD VSS sg13cmos5l_decap_8
X_5890_ _7696_/D _5890_/A _5934_/A VDD VSS sg13cmos5l_nor2b_2
X_4910_ _4975_/B _4974_/B _4974_/A VDD VSS sg13cmos5l_xor2_1
X_4841_ _4851_/A _4905_/A _4841_/B VDD VSS sg13cmos5l_xnor2_1
XFILLER_60_240 VDD VSS sg13cmos5l_decap_8
XFILLER_61_741 VDD VSS sg13cmos5l_fill_1
XFILLER_61_785 VDD VSS sg13cmos5l_decap_8
X_7560_ _7561_/C _7613_/C _7560_/B _7616_/A VDD VSS sg13cmos5l_nand3_1
X_4772_ _4773_/B _4818_/A _4818_/B VDD VSS sg13cmos5l_xor2_1
X_6511_ _6512_/B _6519_/A _6510_/X _6527_/A VDD VSS sg13cmos5l_o21ai_1
X_7491_ _7493_/A _7491_/A _7594_/B VDD VSS sg13cmos5l_nand2_1
X_6442_ _6442_/Y _6442_/A _6441_/A VDD VSS sg13cmos5l_nor2b_1
X_6373_ _6815_/A _6373_/A _6375_/B VDD VSS sg13cmos5l_nor2b_1
X_5324_ _5325_/B _5745_/B1 _5447_/A _5684_/B1 _5448_/A VDD VSS sg13cmos5l_a22oi_1
X_5255_ _5256_/B _5557_/B1 _4996_/X _5493_/B1 _4997_/X VDD VSS sg13cmos5l_a22oi_1
XFILLER_69_863 VDD VSS sg13cmos5l_decap_4
X_4206_ _4207_/B _4738_/B1 _4047_/A _4675_/B1 _4076_/A VDD VSS sg13cmos5l_a22oi_1
XFILLER_69_896 VDD VSS sg13cmos5l_fill_2
XFILLER_68_362 VDD VSS sg13cmos5l_fill_2
X_5186_ _5186_/Y _5186_/A _5153_/B VDD VSS sg13cmos5l_nor2b_1
XFILLER_56_502 VDD VSS sg13cmos5l_decap_8
X_4137_ _4146_/B _4147_/A _4148_/A VDD VSS sg13cmos5l_xor2_1
XFILLER_68_395 VDD VSS sg13cmos5l_decap_4
X_4068_ _4109_/B _4068_/A _4068_/B VDD VSS sg13cmos5l_nor2_1
XFILLER_71_549 VDD VSS sg13cmos5l_fill_1
XFILLER_71_538 VDD VSS sg13cmos5l_decap_8
XFILLER_36_270 VDD VSS sg13cmos5l_decap_8
XFILLER_40_903 VDD VSS sg13cmos5l_decap_8
X_7689_ _7689_/Q clkload0/A _7689_/D fanout385/X VDD VSS sg13cmos5l_dfrbpq_1
X_6709_ _6713_/B _6780_/A _6780_/B _6779_/B VDD VSS sg13cmos5l_nand3_1
XFILLER_22_11 VDD VSS sg13cmos5l_fill_1
XFILLER_78_115 VDD VSS sg13cmos5l_decap_8
XFILLER_75_822 VDD VSS sg13cmos5l_fill_2
Xfanout183 _6641_/C _6649_/A VDD VSS sg13cmos5l_buf_1
Xfanout194 _6391_/A _6372_/C VDD VSS sg13cmos5l_buf_1
XFILLER_47_96 VDD VSS sg13cmos5l_decap_8
XFILLER_47_568 VDD VSS sg13cmos5l_fill_2
XFILLER_74_376 VDD VSS sg13cmos5l_fill_1
XFILLER_42_240 VDD VSS sg13cmos5l_fill_2
XFILLER_63_84 VDD VSS sg13cmos5l_decap_8
XFILLER_69_148 VDD VSS sg13cmos5l_decap_8
X_5040_ _5101_/A _5040_/A _5040_/B VDD VSS sg13cmos5l_and2_1
XFILLER_33_4 VDD VSS sg13cmos5l_fill_1
XFILLER_78_660 VDD VSS sg13cmos5l_decap_8
XFILLER_38_546 VDD VSS sg13cmos5l_fill_2
XFILLER_65_321 VDD VSS sg13cmos5l_decap_4
X_6991_ _6992_/A _6991_/A _6991_/B VDD VSS sg13cmos5l_nand2_1
X_5942_ _5946_/A _5982_/A _5942_/B VDD VSS sg13cmos5l_xnor2_1
XFILLER_80_346 VDD VSS sg13cmos5l_decap_8
X_5873_ _5874_/B _5913_/A _5913_/B VDD VSS sg13cmos5l_xor2_1
X_4824_ _4827_/A _3931_/A _5190_/A _4944_/A VDD VSS sg13cmos5l_a21oi_1
X_7612_ _7634_/B _7657_/A _7612_/B VDD VSS sg13cmos5l_nand2_2
X_7543_ _7544_/B _7543_/A _7543_/B VDD VSS sg13cmos5l_nand2_1
Xrebuffer706 rebuffer706/X rebuffer707/X VDD VSS sg13cmos5l_buf_1
X_4755_ _4756_/B _5178_/B1 _4876_/A _4574_/X _4877_/A VDD VSS sg13cmos5l_a22oi_1
Xrebuffer728 _7563_/A1 _7368_/A VDD VSS sg13cmos5l_buf_1
Xrebuffer739 rebuffer739/X rebuffer740/X VDD VSS sg13cmos5l_buf_1
Xrebuffer717 rebuffer717/X rebuffer718/X VDD VSS sg13cmos5l_buf_1
X_7474_ _7475_/A _7594_/A _7595_/A _7594_/B _7597_/B VDD VSS sg13cmos5l_nand4_1
X_4686_ _4687_/B _4433_/X _4429_/X _4920_/B1 _4430_/X VDD VSS sg13cmos5l_a22oi_1
XFILLER_108_25 VDD VSS sg13cmos5l_decap_4
X_6425_ _6821_/B _6413_/B _7673_/Q VDD VSS sg13cmos5l_nand2b_1
Xbank_A_sram.gen_ihp_256x32.u_sram_256x32 input16/X input15/X bank_A_sram.gen_ihp_256x32.u_sram_256x32_451/L_LO
+ bank_A_sram.gen_ihp_256x32.u_sram_256x32_450/L_LO bank_A_sram.gen_ihp_256x32.u_sram_256x32_564/L_HI
+ bank_A_sram.gen_ihp_256x32.u_sram_256x32_563/L_HI bank_A_sram.gen_ihp_256x32.u_sram_256x32_418/L_LO
+ bank_A_sram.gen_ihp_256x32.u_sram_256x32_417/L_LO _4586_/A _4522_/A VSS VDD VDD
+ input17/X input14/X bank_A_sram.gen_ihp_256x32.u_sram_256x32_452/L_LO bank_A_sram.gen_ihp_256x32.u_sram_256x32_449/L_LO
+ bank_A_sram.gen_ihp_256x32.u_sram_256x32_565/L_HI bank_A_sram.gen_ihp_256x32.u_sram_256x32_562/L_HI
+ bank_A_sram.gen_ihp_256x32.u_sram_256x32_419/L_LO bank_A_sram.gen_ihp_256x32.u_sram_256x32_416/L_LO
+ _4644_/A _4444_/A input18/X input13/X bank_A_sram.gen_ihp_256x32.u_sram_256x32_453/L_LO
+ bank_A_sram.gen_ihp_256x32.u_sram_256x32_448/L_LO bank_A_sram.gen_ihp_256x32.u_sram_256x32_566/L_HI
+ bank_A_sram.gen_ihp_256x32.u_sram_256x32_561/L_HI bank_A_sram.gen_ihp_256x32.u_sram_256x32_420/L_LO
+ bank_A_sram.gen_ihp_256x32.u_sram_256x32_415/L_LO _4699_/A _4386_/A input19/X input12/X
+ bank_A_sram.gen_ihp_256x32.u_sram_256x32_454/L_LO bank_A_sram.gen_ihp_256x32.u_sram_256x32_447/L_LO
+ bank_A_sram.gen_ihp_256x32.u_sram_256x32_567/L_HI bank_A_sram.gen_ihp_256x32.u_sram_256x32_560/L_HI
+ bank_A_sram.gen_ihp_256x32.u_sram_256x32_421/L_LO bank_A_sram.gen_ihp_256x32.u_sram_256x32_414/L_LO
+ _4764_/A _4324_/A input21/X input11/X bank_A_sram.gen_ihp_256x32.u_sram_256x32_455/L_LO
+ bank_A_sram.gen_ihp_256x32.u_sram_256x32_446/L_LO bank_A_sram.gen_ihp_256x32.u_sram_256x32_568/L_HI
+ bank_A_sram.gen_ihp_256x32.u_sram_256x32_559/L_HI bank_A_sram.gen_ihp_256x32.u_sram_256x32_422/L_LO
+ bank_A_sram.gen_ihp_256x32.u_sram_256x32_413/L_LO _4823_/A _4273_/A input22/X input10/X
+ bank_A_sram.gen_ihp_256x32.u_sram_256x32_456/L_LO bank_A_sram.gen_ihp_256x32.u_sram_256x32_445/L_LO
+ bank_A_sram.gen_ihp_256x32.u_sram_256x32_569/L_HI bank_A_sram.gen_ihp_256x32.u_sram_256x32_558/L_HI
+ bank_A_sram.gen_ihp_256x32.u_sram_256x32_423/L_LO bank_A_sram.gen_ihp_256x32.u_sram_256x32_412/L_LO
+ _4886_/A _4216_/A input23/X input40/X bank_A_sram.gen_ihp_256x32.u_sram_256x32_457/L_LO
+ bank_A_sram.gen_ihp_256x32.u_sram_256x32_444/L_LO bank_A_sram.gen_ihp_256x32.u_sram_256x32_570/L_HI
+ bank_A_sram.gen_ihp_256x32.u_sram_256x32/A_BM[9] bank_A_sram.gen_ihp_256x32.u_sram_256x32_424/L_LO
+ bank_A_sram.gen_ihp_256x32.u_sram_256x32_411/L_LO _4943_/A _4169_/A input24/X input39/X
+ bank_A_sram.gen_ihp_256x32.u_sram_256x32_458/L_LO bank_A_sram.gen_ihp_256x32.u_sram_256x32_443/L_LO
+ bank_A_sram.gen_ihp_256x32.u_sram_256x32_571/L_HI bank_A_sram.gen_ihp_256x32.u_sram_256x32/A_BM[8]
+ bank_A_sram.gen_ihp_256x32.u_sram_256x32_425/L_LO bank_A_sram.gen_ihp_256x32.u_sram_256x32_410/L_LO
+ _5011_/A _4125_/A input25/X input38/X bank_A_sram.gen_ihp_256x32.u_sram_256x32_459/L_LO
+ bank_A_sram.gen_ihp_256x32.u_sram_256x32_442/L_LO bank_A_sram.gen_ihp_256x32.u_sram_256x32_572/L_HI
+ bank_A_sram.gen_ihp_256x32.u_sram_256x32/A_BM[7] bank_A_sram.gen_ihp_256x32.u_sram_256x32_426/L_LO
+ bank_A_sram.gen_ihp_256x32.u_sram_256x32_409/L_LO _5074_/A _4083_/A input26/X input37/X
+ bank_A_sram.gen_ihp_256x32.u_sram_256x32_460/L_LO bank_A_sram.gen_ihp_256x32.u_sram_256x32_441/L_LO
+ bank_A_sram.gen_ihp_256x32.u_sram_256x32_573/L_HI bank_A_sram.gen_ihp_256x32.u_sram_256x32/A_BM[6]
+ bank_A_sram.gen_ihp_256x32.u_sram_256x32_427/L_LO bank_A_sram.gen_ihp_256x32.u_sram_256x32_408/L_LO
+ _5143_/A _4054_/A input27/X input36/X bank_A_sram.gen_ihp_256x32.u_sram_256x32_461/L_LO
+ bank_A_sram.gen_ihp_256x32.u_sram_256x32_440/L_LO bank_A_sram.gen_ihp_256x32.u_sram_256x32_574/L_HI
+ bank_A_sram.gen_ihp_256x32.u_sram_256x32/A_BM[5] bank_A_sram.gen_ihp_256x32.u_sram_256x32_428/L_LO
+ bank_A_sram.gen_ihp_256x32.u_sram_256x32_407/L_LO _5203_/A _4021_/A input28/X input35/X
+ bank_A_sram.gen_ihp_256x32.u_sram_256x32_462/L_LO bank_A_sram.gen_ihp_256x32.u_sram_256x32_439/L_LO
+ bank_A_sram.gen_ihp_256x32.u_sram_256x32_575/L_HI bank_A_sram.gen_ihp_256x32.u_sram_256x32/A_BM[4]
+ bank_A_sram.gen_ihp_256x32.u_sram_256x32_429/L_LO bank_A_sram.gen_ihp_256x32.u_sram_256x32_406/L_LO
+ _5272_/A _4001_/A input29/X input34/X bank_A_sram.gen_ihp_256x32.u_sram_256x32_463/L_LO
+ bank_A_sram.gen_ihp_256x32.u_sram_256x32_438/L_LO bank_A_sram.gen_ihp_256x32.u_sram_256x32_576/L_HI
+ bank_A_sram.gen_ihp_256x32.u_sram_256x32/A_BM[3] bank_A_sram.gen_ihp_256x32.u_sram_256x32_430/L_LO
+ bank_A_sram.gen_ihp_256x32.u_sram_256x32_405/L_LO _5332_/A _3973_/A input30/X input31/X
+ bank_A_sram.gen_ihp_256x32.u_sram_256x32_464/L_LO bank_A_sram.gen_ihp_256x32.u_sram_256x32_437/L_LO
+ bank_A_sram.gen_ihp_256x32.u_sram_256x32_577/L_HI bank_A_sram.gen_ihp_256x32.u_sram_256x32/A_BM[2]
+ bank_A_sram.gen_ihp_256x32.u_sram_256x32_431/L_LO bank_A_sram.gen_ihp_256x32.u_sram_256x32_404/L_LO
+ _5393_/A _3958_/A input32/X input20/X bank_A_sram.gen_ihp_256x32.u_sram_256x32_465/L_LO
+ bank_A_sram.gen_ihp_256x32.u_sram_256x32_436/L_LO bank_A_sram.gen_ihp_256x32.u_sram_256x32_578/L_HI
+ bank_A_sram.gen_ihp_256x32.u_sram_256x32/A_BM[1] bank_A_sram.gen_ihp_256x32.u_sram_256x32_432/L_LO
+ bank_A_sram.gen_ihp_256x32.u_sram_256x32_403/L_LO _5457_/A wire373/A input33/X input9/X
+ bank_A_sram.gen_ihp_256x32.u_sram_256x32_466/L_LO bank_A_sram.gen_ihp_256x32.u_sram_256x32_435/L_LO
+ bank_A_sram.gen_ihp_256x32.u_sram_256x32_579/L_HI bank_A_sram.gen_ihp_256x32.u_sram_256x32/A_BM[0]
+ bank_A_sram.gen_ihp_256x32.u_sram_256x32_433/L_LO bank_A_sram.gen_ihp_256x32.u_sram_256x32_402/L_LO
+ _5516_/A wire374/A input1/X bank_A_sram.gen_ihp_256x32.u_sram_256x32_394/L_LO input2/X
+ bank_A_sram.gen_ihp_256x32.u_sram_256x32_395/L_LO input3/X bank_A_sram.gen_ihp_256x32.u_sram_256x32_396/L_LO
+ input4/X bank_A_sram.gen_ihp_256x32.u_sram_256x32_397/L_LO input5/X bank_A_sram.gen_ihp_256x32.u_sram_256x32_398/L_LO
+ input6/X bank_A_sram.gen_ihp_256x32.u_sram_256x32_399/L_LO input7/X bank_A_sram.gen_ihp_256x32.u_sram_256x32_400/L_LO
+ input8/X bank_A_sram.gen_ihp_256x32.u_sram_256x32_401/L_LO clkbuf_1_1__f_clk_i/X
+ _3927_/Y _3927_/A bank_A_sram.gen_ihp_256x32.u_sram_256x32/A_MEN bank_A_sram.gen_ihp_256x32.u_sram_256x32/A_DLY
+ bank_A_sram.gen_ihp_256x32.u_sram_256x32_467/L_LO bank_A_sram.gen_ihp_256x32.u_sram_256x32_434/L_LO
+ bank_A_sram.gen_ihp_256x32.u_sram_256x32_469/L_LO bank_A_sram.gen_ihp_256x32.u_sram_256x32_470/L_LO
+ bank_A_sram.gen_ihp_256x32.u_sram_256x32_468/L_LO RM_IHPSG13_1P_256x32_c2_bm_bist
X_6356_ _6507_/A _6356_/A _6918_/B _6909_/B VDD VSS sg13cmos5l_nand3_1
X_5307_ _5307_/Y _5307_/A _5307_/B VDD VSS sg13cmos5l_nor2_1
X_6287_ _6288_/B _6287_/A _7661_/Q _6317_/C VDD VSS sg13cmos5l_nand3_1
X_5238_ _5239_/B _5238_/A _5238_/B VDD VSS sg13cmos5l_nand2_1
X_5169_ _5169_/Y _5106_/B _5107_/A _5168_/Y VDD VSS sg13cmos5l_o21ai_1
XFILLER_57_833 VDD VSS sg13cmos5l_decap_4
XFILLER_68_192 VDD VSS sg13cmos5l_decap_8
XFILLER_71_324 VDD VSS sg13cmos5l_decap_4
XFILLER_71_313 VDD VSS sg13cmos5l_decap_4
Xbank_B_sram.gen_ihp_256x32.u_sram_256x32_603 bank_B_sram.gen_ihp_256x32.u_sram_256x32_603/L_HI
+ VDD VSS sg13cmos5l_tiehi
Xbank_B_sram.gen_ihp_256x32.u_sram_256x32_614 bank_B_sram.gen_ihp_256x32.u_sram_256x32/A_DLY
+ VDD VSS sg13cmos5l_tiehi
XFILLER_44_538 VDD VSS sg13cmos5l_decap_8
XFILLER_40_733 VDD VSS sg13cmos5l_decap_8
XFILLER_79_446 VDD VSS sg13cmos5l_decap_8
XFILLER_58_40 VDD VSS sg13cmos5l_fill_1
XFILLER_79_479 VDD VSS sg13cmos5l_decap_8
XFILLER_75_685 VDD VSS sg13cmos5l_fill_1
XFILLER_35_516 VDD VSS sg13cmos5l_fill_2
XFILLER_63_825 VDD VSS sg13cmos5l_fill_1
XFILLER_74_72 VDD VSS sg13cmos5l_fill_1
XFILLER_62_357 VDD VSS sg13cmos5l_fill_2
XFILLER_43_571 VDD VSS sg13cmos5l_decap_8
X_4540_ _4553_/A _4460_/B _4460_/A _4539_/X VDD VSS sg13cmos5l_a21o_1
X_4471_ _4473_/A _4471_/A _4471_/B VDD VSS sg13cmos5l_nor2_1
X_6210_ _6211_/A _6212_/A input82/X VDD VSS sg13cmos5l_nor2b_1
X_7190_ _7190_/Y _7188_/Y _7248_/A _7265_/A VDD VSS sg13cmos5l_a21oi_1
X_6141_ _6143_/A _6163_/A _6141_/B VDD VSS sg13cmos5l_xnor2_1
X_6072_ _6103_/B _6128_/A _6072_/B VDD VSS sg13cmos5l_xnor2_1
XFILLER_78_490 VDD VSS sg13cmos5l_fill_2
X_5023_ _5024_/B _5023_/A _5092_/B VDD VSS sg13cmos5l_xor2_1
XFILLER_66_641 VDD VSS sg13cmos5l_decap_4
XFILLER_65_140 VDD VSS sg13cmos5l_fill_1
XFILLER_54_836 VDD VSS sg13cmos5l_fill_2
XFILLER_54_847 VDD VSS sg13cmos5l_fill_2
XFILLER_81_666 VDD VSS sg13cmos5l_decap_8
XFILLER_80_143 VDD VSS sg13cmos5l_decap_8
XFILLER_54_869 VDD VSS sg13cmos5l_decap_8
X_6974_ _6974_/Y _6974_/A _6974_/B VDD VSS sg13cmos5l_nand2_1
X_5925_ _5967_/A _5925_/A _5937_/A VDD VSS sg13cmos5l_xor2_1
X_5856_ _5923_/B _5854_/Y _5820_/B _5855_/Y VDD VSS sg13cmos5l_o21ai_1
X_4807_ _4807_/Y _4807_/A _4774_/B VDD VSS sg13cmos5l_nor2b_1
X_5787_ _7694_/D _5787_/A _5846_/A VDD VSS sg13cmos5l_nor2b_1
X_7526_ _7618_/A _7526_/A _7526_/B VDD VSS sg13cmos5l_xnor2_1
X_4738_ _4798_/S _4799_/B1 _5309_/A _4738_/B1 _5116_/A VDD VSS sg13cmos5l_a22oi_1
X_7457_ _7492_/B _7451_/B _7603_/A VDD VSS sg13cmos5l_nand2b_1
X_4669_ _4727_/A _4613_/A _4613_/B _4668_/X VDD VSS sg13cmos5l_a21o_1
XFILLER_79_39 VDD VSS sg13cmos5l_decap_4
X_6408_ _6410_/B _6408_/A _6688_/B VDD VSS sg13cmos5l_nand2_1
X_7388_ _7509_/A _7388_/A VDD VSS sg13cmos5l_inv_1
Xbank_A_sram.gen_ihp_256x32.u_sram_256x32_407 bank_A_sram.gen_ihp_256x32.u_sram_256x32_407/L_LO
+ VDD VSS sg13cmos5l_tielo
X_6339_ _6790_/A _6339_/A _6341_/B VDD VSS sg13cmos5l_nor2b_2
Xbank_A_sram.gen_ihp_256x32.u_sram_256x32_418 bank_A_sram.gen_ihp_256x32.u_sram_256x32_418/L_LO
+ VDD VSS sg13cmos5l_tielo
Xbank_A_sram.gen_ihp_256x32.u_sram_256x32_429 bank_A_sram.gen_ihp_256x32.u_sram_256x32_429/L_LO
+ VDD VSS sg13cmos5l_tielo
XFILLER_76_416 VDD VSS sg13cmos5l_fill_2
XFILLER_49_619 VDD VSS sg13cmos5l_decap_8
XFILLER_76_438 VDD VSS sg13cmos5l_fill_1
XFILLER_45_803 VDD VSS sg13cmos5l_fill_2
XFILLER_56_140 VDD VSS sg13cmos5l_decap_8
XFILLER_72_611 VDD VSS sg13cmos5l_fill_2
XFILLER_44_324 VDD VSS sg13cmos5l_decap_8
XFILLER_71_176 VDD VSS sg13cmos5l_fill_1
Xbank_B_sram.gen_ihp_256x32.u_sram_256x32_477 bank_B_sram.gen_ihp_256x32.u_sram_256x32_477/L_LO
+ VDD VSS sg13cmos5l_tielo
XFILLER_44_20 VDD VSS sg13cmos5l_decap_4
Xbank_B_sram.gen_ihp_256x32.u_sram_256x32_499 bank_B_sram.gen_ihp_256x32.u_sram_256x32_499/L_LO
+ VDD VSS sg13cmos5l_tielo
Xbank_B_sram.gen_ihp_256x32.u_sram_256x32_488 bank_B_sram.gen_ihp_256x32.u_sram_256x32_488/L_LO
+ VDD VSS sg13cmos5l_tielo
XFILLER_53_880 VDD VSS sg13cmos5l_fill_1
XFILLER_53_891 VDD VSS sg13cmos5l_decap_4
XFILLER_40_563 VDD VSS sg13cmos5l_decap_8
XFILLER_40_574 VDD VSS sg13cmos5l_fill_1
XFILLER_69_83 VDD VSS sg13cmos5l_fill_2
XFILLER_79_254 VDD VSS sg13cmos5l_decap_8
XFILLER_68_928 VDD VSS sg13cmos5l_decap_4
XFILLER_67_427 VDD VSS sg13cmos5l_fill_2
XFILLER_82_419 VDD VSS sg13cmos5l_fill_2
XFILLER_35_302 VDD VSS sg13cmos5l_fill_2
XFILLER_36_858 VDD VSS sg13cmos5l_decap_8
X_3971_ _3987_/A _5645_/A _3970_/A _3970_/Y VDD VSS sg13cmos5l_a21oi_2
XFILLER_35_368 VDD VSS sg13cmos5l_decap_4
XFILLER_51_817 VDD VSS sg13cmos5l_fill_1
XFILLER_63_666 VDD VSS sg13cmos5l_decap_4
XFILLER_63_677 VDD VSS sg13cmos5l_fill_2
X_5710_ _5754_/B _5710_/A _5710_/B VDD VSS sg13cmos5l_nand2_1
XFILLER_44_891 VDD VSS sg13cmos5l_fill_2
X_6690_ _6690_/Y _6690_/A _6689_/A VDD VSS sg13cmos5l_nor2b_1
X_5641_ _5642_/B _5712_/A _5756_/A2 _5698_/A _5756_/B2 VDD VSS sg13cmos5l_a22oi_1
X_5572_ _5572_/X _5572_/A VDD VSS sg13cmos5l_buf_1
X_4523_ _4526_/A _3931_/A _4872_/A _4944_/A VDD VSS sg13cmos5l_a21oi_1
X_7311_ _7312_/A _7311_/A _7311_/B VDD VSS sg13cmos5l_nand2_1
X_7242_ _7257_/A _6630_/A _7234_/Y _7241_/Y VDD VSS sg13cmos5l_o21ai_1
X_4454_ _4455_/B _4506_/A _4454_/B VDD VSS sg13cmos5l_xnor2_1
Xrebuffer1202 _4189_/A _4143_/A VDD VSS sg13cmos5l_buf_1
X_4385_ _4396_/A _4761_/A _4385_/B VDD VSS sg13cmos5l_xnor2_1
X_7173_ _7174_/B _7167_/Y _7313_/A _7172_/Y VDD VSS sg13cmos5l_a21oi_1
Xrebuffer1235 _5785_/A1 _5786_/A VDD VSS sg13cmos5l_buf_1
Xrebuffer1213 rebuffer1213/X rebuffer1214/X VDD VSS sg13cmos5l_buf_1
Xrebuffer1224 rebuffer1224/X rebuffer1225/X VDD VSS sg13cmos5l_buf_1
Xrebuffer1246 rebuffer1246/X rebuffer1247/X VDD VSS sg13cmos5l_buf_1
X_6124_ _6124_/Y _6124_/A _6124_/B VDD VSS sg13cmos5l_nand2_1
X_6055_ _6123_/B _6055_/A VDD VSS sg13cmos5l_buf_1
X_5006_ _5022_/A _5006_/A _5006_/B VDD VSS sg13cmos5l_xor2_1
XFILLER_39_674 VDD VSS sg13cmos5l_decap_8
XFILLER_38_151 VDD VSS sg13cmos5l_decap_8
XFILLER_53_110 VDD VSS sg13cmos5l_fill_1
XFILLER_41_305 VDD VSS sg13cmos5l_decap_8
XFILLER_53_143 VDD VSS sg13cmos5l_fill_1
X_6957_ _6958_/B _6827_/Y _6824_/A _6957_/S VDD VSS sg13cmos5l_mux2_1
XFILLER_35_880 VDD VSS sg13cmos5l_decap_4
X_6888_ _6888_/Y _6937_/A _7101_/A VDD VSS sg13cmos5l_nor2_1
X_5908_ _5916_/A _5862_/B _5415_/A _5908_/S VDD VSS sg13cmos5l_mux2_1
X_5839_ _5843_/B _6128_/A _5885_/A VDD VSS sg13cmos5l_xnor2_1
X_7509_ _7511_/A _7509_/A _7509_/B VDD VSS sg13cmos5l_nand2_1
XFILLER_49_405 VDD VSS sg13cmos5l_decap_8
XFILLER_39_64 VDD VSS sg13cmos5l_decap_8
XFILLER_44_110 VDD VSS sg13cmos5l_fill_2
XFILLER_55_41 VDD VSS sg13cmos5l_fill_1
XFILLER_45_699 VDD VSS sg13cmos5l_decap_4
XFILLER_71_62 VDD VSS sg13cmos5l_fill_1
XFILLER_41_872 VDD VSS sg13cmos5l_decap_8
XFILLER_71_95 VDD VSS sg13cmos5l_decap_8
X_4170_ _4173_/A _3955_/A _4511_/A _4387_/A VDD VSS sg13cmos5l_a21oi_1
XFILLER_68_769 VDD VSS sg13cmos5l_decap_8
XFILLER_48_460 VDD VSS sg13cmos5l_fill_1
XFILLER_55_408 VDD VSS sg13cmos5l_decap_4
XFILLER_82_227 VDD VSS sg13cmos5l_decap_8
XFILLER_35_110 VDD VSS sg13cmos5l_decap_8
XFILLER_63_430 VDD VSS sg13cmos5l_fill_1
X_6811_ _6811_/Y _6811_/A _6811_/B VDD VSS sg13cmos5l_xnor2_1
XFILLER_63_463 VDD VSS sg13cmos5l_fill_1
X_3954_ _3967_/A _3970_/A _3968_/A VDD VSS sg13cmos5l_nand2_1
X_6742_ _6744_/A _6742_/A _6742_/B VDD VSS sg13cmos5l_nand2_1
X_6673_ _6675_/A _6674_/A _6684_/C _7703_/Q VDD VSS sg13cmos5l_a21oi_1
XFILLER_50_179 VDD VSS sg13cmos5l_decap_8
X_5624_ _5625_/B _5793_/A _5624_/B VDD VSS sg13cmos5l_xnor2_1
X_5555_ _5660_/A _5500_/B _5500_/A _5554_/Y VDD VSS sg13cmos5l_a21oi_1
X_4506_ _4506_/Y _4506_/A _4454_/B VDD VSS sg13cmos5l_nor2b_1
X_5486_ _5489_/B _5419_/A _5419_/B _5420_/A VDD VSS sg13cmos5l_o21ai_1
X_7225_ _7226_/A _7225_/A _7248_/A _7225_/C VDD VSS sg13cmos5l_nand3_1
X_4437_ _4500_/B _4875_/A _4437_/B VDD VSS sg13cmos5l_xnor2_1
X_7156_ _7156_/Y _7205_/A _7156_/B VDD VSS sg13cmos5l_nor2_1
X_6107_ _6109_/A _6123_/B _6107_/B VDD VSS sg13cmos5l_nor2_1
X_4368_ _4417_/B _4621_/A _4368_/B VDD VSS sg13cmos5l_xnor2_1
X_4299_ _6111_/B _4508_/A _4300_/B VDD VSS sg13cmos5l_nor2_1
X_7087_ _7087_/Y _7087_/A _7087_/B VDD VSS sg13cmos5l_nor2_1
X_6038_ _6048_/A _5996_/B _6036_/Y _6037_/Y VDD VSS sg13cmos5l_a21oi_1
XFILLER_82_750 VDD VSS sg13cmos5l_decap_4
XFILLER_70_901 VDD VSS sg13cmos5l_fill_1
XFILLER_81_282 VDD VSS sg13cmos5l_decap_8
XFILLER_25_22 VDD VSS sg13cmos5l_decap_8
XFILLER_42_658 VDD VSS sg13cmos5l_fill_1
XFILLER_41_21 VDD VSS sg13cmos5l_decap_4
XFILLER_41_87 VDD VSS sg13cmos5l_decap_8
XFILLER_77_500 VDD VSS sg13cmos5l_decap_8
XFILLER_2_26 VDD VSS sg13cmos5l_fill_2
XFILLER_77_544 VDD VSS sg13cmos5l_decap_8
XFILLER_37_408 VDD VSS sg13cmos5l_decap_8
XFILLER_49_279 VDD VSS sg13cmos5l_fill_2
XFILLER_64_227 VDD VSS sg13cmos5l_fill_1
XFILLER_80_709 VDD VSS sg13cmos5l_fill_1
XFILLER_72_282 VDD VSS sg13cmos5l_decap_4
XFILLER_60_433 VDD VSS sg13cmos5l_fill_2
Xoutput116 bank_A_rdata[0] _3932_/A VDD VSS sg13cmos5l_buf_1
X_5340_ _5341_/B _5389_/A _5389_/B VDD VSS sg13cmos5l_xor2_1
Xoutput127 bank_A_rdata[1] _3936_/A VDD VSS sg13cmos5l_buf_1
Xoutput138 bank_A_rdata[2] _3958_/A VDD VSS sg13cmos5l_buf_1
X_5271_ _5281_/A _5810_/B _5271_/B VDD VSS sg13cmos5l_xnor2_1
Xoutput149 bank_B_rdata[10] output149/A VDD VSS sg13cmos5l_buf_1
X_4222_ _4223_/B _4433_/A _3950_/X _4375_/A _3981_/X VDD VSS sg13cmos5l_a22oi_1
X_7010_ _7096_/A _7010_/A _7059_/A VDD VSS sg13cmos5l_nand2_2
X_4153_ _4153_/Y _4153_/A _4153_/B VDD VSS sg13cmos5l_nand2_1
X_4084_ _4087_/A _3955_/A _4375_/A _3961_/A VDD VSS sg13cmos5l_a21oi_1
XFILLER_52_923 VDD VSS sg13cmos5l_decap_8
XFILLER_64_783 VDD VSS sg13cmos5l_decap_8
X_4986_ _5049_/S _5050_/B1 _4737_/X _4986_/B1 _5116_/A VDD VSS sg13cmos5l_a22oi_1
X_3937_ _3937_/X _3937_/A VDD VSS sg13cmos5l_buf_1
X_6725_ _6726_/A _6721_/Y _6896_/B _6724_/X VDD VSS sg13cmos5l_a21oi_1
XFILLER_51_499 VDD VSS sg13cmos5l_decap_8
X_6656_ _6664_/A _6656_/A _6656_/B VDD VSS sg13cmos5l_nand2_1
X_6587_ _6603_/A _6587_/A _6587_/B VDD VSS sg13cmos5l_nor2_2
X_5607_ _5609_/A _5608_/A _5608_/C _5608_/B VDD VSS sg13cmos5l_a21o_1
X_5538_ _5541_/A _5538_/A VDD VSS sg13cmos5l_inv_1
XFILLER_79_809 VDD VSS sg13cmos5l_fill_1
X_7208_ _7208_/Y _7248_/A _6859_/Y _7207_/Y VDD VSS sg13cmos5l_o21ai_1
X_5469_ _5470_/B _5469_/A _5531_/B VDD VSS sg13cmos5l_xor2_1
Xfanout321 _5985_/B1 _5505_/X VDD VSS sg13cmos5l_buf_1
XFILLER_59_500 VDD VSS sg13cmos5l_fill_1
Xfanout310 _6943_/A _6964_/S VDD VSS sg13cmos5l_buf_1
Xfanout332 _5557_/B1 _5000_/X VDD VSS sg13cmos5l_buf_1
Xfanout354 _4172_/B _3956_/X VDD VSS sg13cmos5l_buf_1
Xfanout343 _5050_/B1 _4511_/X VDD VSS sg13cmos5l_buf_1
Xfanout365 _5245_/A _4922_/A VDD VSS sg13cmos5l_buf_1
X_7139_ _7296_/B _7164_/A _6959_/Y _7138_/Y VDD VSS sg13cmos5l_o21ai_1
Xfanout387 fanout387/X fanout391/X VDD VSS sg13cmos5l_buf_1
Xfanout376 _4621_/A _4676_/A VDD VSS sg13cmos5l_buf_1
XFILLER_36_32 VDD VSS sg13cmos5l_decap_8
XFILLER_52_42 VDD VSS sg13cmos5l_fill_1
XFILLER_52_31 VDD VSS sg13cmos5l_decap_8
XFILLER_52_64 VDD VSS sg13cmos5l_decap_4
Xinput18 input18/X bank_A_wdata[18] VDD VSS sg13cmos5l_buf_1
Xinput29 input29/X bank_A_wdata[28] VDD VSS sg13cmos5l_buf_1
XFILLER_35_8 VDD VSS sg13cmos5l_decap_8
XFILLER_77_341 VDD VSS sg13cmos5l_fill_1
XFILLER_37_238 VDD VSS sg13cmos5l_fill_1
XFILLER_65_536 VDD VSS sg13cmos5l_fill_2
XFILLER_46_794 VDD VSS sg13cmos5l_fill_1
X_4840_ _4841_/B _4840_/A _4840_/B VDD VSS sg13cmos5l_xor2_1
X_4771_ _4818_/B _4771_/A _4771_/B VDD VSS sg13cmos5l_xnor2_1
X_6510_ _6510_/X _6518_/C _6518_/B VDD VSS sg13cmos5l_and2_1
X_7490_ _7629_/A _7605_/B _7605_/A VDD VSS sg13cmos5l_xnor2_1
X_6441_ _6457_/A _6441_/A _6441_/B VDD VSS sg13cmos5l_nor2_2
X_6372_ _6375_/B _6372_/A _7669_/Q _6372_/C VDD VSS sg13cmos5l_nand3_1
X_5323_ _5374_/A _5442_/A _5323_/B VDD VSS sg13cmos5l_xnor2_1
X_5254_ _5284_/A _5214_/B _5214_/A _5253_/Y VDD VSS sg13cmos5l_a21oi_1
XFILLER_69_831 VDD VSS sg13cmos5l_fill_1
X_4205_ _4205_/X _4205_/A VDD VSS sg13cmos5l_buf_1
X_5185_ _5286_/B _5185_/A _5185_/B VDD VSS sg13cmos5l_xor2_1
X_4136_ _4148_/A _4181_/A _4136_/B VDD VSS sg13cmos5l_xnor2_1
XFILLER_113_15 VDD VSS sg13cmos5l_decap_8
X_4067_ _4108_/B _4067_/A _4067_/B VDD VSS sg13cmos5l_nor2_1
XFILLER_56_569 VDD VSS sg13cmos5l_decap_8
XFILLER_71_528 VDD VSS sg13cmos5l_decap_4
XFILLER_52_764 VDD VSS sg13cmos5l_decap_8
XFILLER_52_797 VDD VSS sg13cmos5l_fill_1
X_4969_ _4970_/B _4969_/A _4969_/B VDD VSS sg13cmos5l_nand2_1
X_6708_ _6713_/A _6779_/A _6780_/C VDD VSS sg13cmos5l_nand2_1
X_7688_ _7688_/Q _7724_/CLK _7688_/D fanout382/X VDD VSS sg13cmos5l_dfrbpq_1
X_6639_ _6641_/A _6647_/C _6647_/A VDD VSS sg13cmos5l_xnor2_1
XFILLER_79_639 VDD VSS sg13cmos5l_fill_2
XFILLER_79_628 VDD VSS sg13cmos5l_decap_8
XFILLER_74_333 VDD VSS sg13cmos5l_decap_8
Xfanout184 _6589_/A _6527_/X VDD VSS sg13cmos5l_buf_1
Xfanout195 _6114_/A _6136_/A VDD VSS sg13cmos5l_buf_1
XFILLER_74_366 VDD VSS sg13cmos5l_fill_2
XFILLER_74_355 VDD VSS sg13cmos5l_decap_8
XFILLER_62_517 VDD VSS sg13cmos5l_decap_4
XFILLER_43_753 VDD VSS sg13cmos5l_decap_8
XFILLER_70_572 VDD VSS sg13cmos5l_decap_8
XFILLER_63_52 VDD VSS sg13cmos5l_fill_1
XFILLER_70_583 VDD VSS sg13cmos5l_fill_1
XFILLER_42_274 VDD VSS sg13cmos5l_decap_8
XFILLER_42_296 VDD VSS sg13cmos5l_decap_8
XFILLER_66_867 VDD VSS sg13cmos5l_fill_1
X_6990_ _6991_/A _6990_/A _7021_/A _6990_/C VDD VSS sg13cmos5l_nand3_1
XFILLER_65_333 VDD VSS sg13cmos5l_fill_1
XFILLER_80_325 VDD VSS sg13cmos5l_decap_8
X_5941_ _5942_/B _6082_/A1 _5941_/A2 _6082_/B1 _5941_/B2 VDD VSS sg13cmos5l_a22oi_1
XFILLER_65_377 VDD VSS sg13cmos5l_fill_1
XFILLER_65_388 VDD VSS sg13cmos5l_fill_2
X_5872_ _5913_/B _5872_/A _5872_/B VDD VSS sg13cmos5l_xnor2_1
X_4823_ _5190_/A _4823_/A VDD VSS sg13cmos5l_buf_1
X_7611_ _7612_/B _7611_/A _7611_/B VDD VSS sg13cmos5l_xnor2_1
X_7542_ _7544_/A _7542_/A _7542_/B VDD VSS sg13cmos5l_nand2_1
X_4754_ _4803_/A _4871_/A _4754_/B VDD VSS sg13cmos5l_xnor2_1
Xrebuffer729 _7516_/A1 _7355_/A VDD VSS sg13cmos5l_buf_1
X_7473_ _7480_/B _7473_/A _7603_/A _7477_/B _7478_/B VDD VSS sg13cmos5l_nand4_1
Xrebuffer718 rebuffer718/X _6573_/A VDD VSS sg13cmos5l_buf_1
Xrebuffer707 rebuffer707/X rebuffer708/X VDD VSS sg13cmos5l_buf_1
X_4685_ _4711_/A _4655_/B _4655_/A _4684_/Y VDD VSS sg13cmos5l_a21oi_1
X_6424_ _6820_/A _6424_/A VDD VSS sg13cmos5l_inv_1
X_6355_ _6981_/A _6355_/A VDD VSS sg13cmos5l_buf_4
X_6286_ _6288_/A _6799_/B _6286_/B VDD VSS sg13cmos5l_nand2_2
X_5306_ _5412_/A _5252_/B _5252_/A _5305_/Y VDD VSS sg13cmos5l_a21oi_1
X_5237_ _5239_/A _5221_/A _5237_/B VDD VSS sg13cmos5l_nand2b_1
XFILLER_69_661 VDD VSS sg13cmos5l_decap_4
X_5168_ _5168_/Y _5101_/A _5104_/Y _5101_/B VDD VSS sg13cmos5l_o21ai_1
XFILLER_56_322 VDD VSS sg13cmos5l_decap_4
X_4119_ _4181_/A _4153_/B _4153_/A VDD VSS sg13cmos5l_xor2_1
X_5099_ _5108_/A _5109_/B _5109_/A VDD VSS sg13cmos5l_xor2_1
XFILLER_56_355 VDD VSS sg13cmos5l_decap_8
XFILLER_57_856 VDD VSS sg13cmos5l_decap_4
Xbank_B_sram.gen_ihp_256x32.u_sram_256x32_604 bank_B_sram.gen_ihp_256x32.u_sram_256x32_604/L_HI
+ VDD VSS sg13cmos5l_tiehi
Xbank_B_sram.gen_ihp_256x32.u_sram_256x32_615 bank_B_sram.gen_ihp_256x32.u_sram_256x32/A_MEN
+ VDD VSS sg13cmos5l_tiehi
XFILLER_56_377 VDD VSS sg13cmos5l_fill_2
XFILLER_71_347 VDD VSS sg13cmos5l_fill_2
XFILLER_79_425 VDD VSS sg13cmos5l_decap_8
XFILLER_79_403 VDD VSS sg13cmos5l_fill_1
XFILLER_47_311 VDD VSS sg13cmos5l_fill_2
XFILLER_75_642 VDD VSS sg13cmos5l_fill_2
XFILLER_48_867 VDD VSS sg13cmos5l_fill_2
XFILLER_35_539 VDD VSS sg13cmos5l_decap_4
XFILLER_62_369 VDD VSS sg13cmos5l_fill_1
XFILLER_70_380 VDD VSS sg13cmos5l_fill_1
X_4470_ _4471_/B _4470_/A VDD VSS sg13cmos5l_inv_1
X_6140_ _6141_/B _5781_/X _6139_/A _6139_/Y VDD VSS sg13cmos5l_o21ai_1
X_6071_ _6072_/B _6100_/B _6100_/A VDD VSS sg13cmos5l_xnor2_1
XFILLER_39_823 VDD VSS sg13cmos5l_decap_4
X_5022_ _5092_/B _5022_/A _5022_/B VDD VSS sg13cmos5l_xor2_1
XFILLER_38_333 VDD VSS sg13cmos5l_fill_2
XFILLER_66_697 VDD VSS sg13cmos5l_decap_4
XFILLER_53_314 VDD VSS sg13cmos5l_fill_1
XFILLER_65_152 VDD VSS sg13cmos5l_decap_8
XFILLER_81_645 VDD VSS sg13cmos5l_decap_8
XFILLER_80_122 VDD VSS sg13cmos5l_decap_8
XFILLER_53_325 VDD VSS sg13cmos5l_fill_1
X_6973_ _6973_/Y _7078_/A _6976_/B _6972_/X VDD VSS sg13cmos5l_a21oi_1
X_5924_ _5937_/A _5881_/A _5922_/Y _5923_/Y VDD VSS sg13cmos5l_o21ai_1
XFILLER_80_199 VDD VSS sg13cmos5l_decap_8
X_5855_ _5855_/Y _5855_/A _5855_/B VDD VSS sg13cmos5l_nand2_1
X_4806_ _4900_/B _4806_/A _4806_/B VDD VSS sg13cmos5l_xor2_1
XFILLER_61_391 VDD VSS sg13cmos5l_decap_4
X_5786_ _5848_/A _5786_/A _5786_/B _5786_/C VDD VSS sg13cmos5l_nand3_1
X_7525_ _7526_/B _7525_/A _7525_/B VDD VSS sg13cmos5l_nand2_1
X_4737_ _4737_/X _4737_/A VDD VSS sg13cmos5l_buf_1
X_7456_ _7467_/B _7456_/A VDD VSS sg13cmos5l_buf_4
X_4668_ _4668_/X _4668_/A _4668_/B VDD VSS sg13cmos5l_and2_1
X_6407_ _6688_/B _6982_/A _6918_/B _6516_/A _6548_/C VDD VSS sg13cmos5l_nor4_1
X_7387_ _7388_/A _7387_/A _7387_/B VDD VSS sg13cmos5l_nor2_1
X_4599_ _4599_/Y _4599_/A _4599_/B VDD VSS sg13cmos5l_nand2_1
Xbank_A_sram.gen_ihp_256x32.u_sram_256x32_408 bank_A_sram.gen_ihp_256x32.u_sram_256x32_408/L_LO
+ VDD VSS sg13cmos5l_tielo
X_6338_ _6341_/B _6338_/A _7666_/Q _6391_/A VDD VSS sg13cmos5l_nand3_1
Xbank_A_sram.gen_ihp_256x32.u_sram_256x32_419 bank_A_sram.gen_ihp_256x32.u_sram_256x32_419/L_LO
+ VDD VSS sg13cmos5l_tielo
X_6269_ _6293_/A _6269_/A VDD VSS sg13cmos5l_buf_4
XFILLER_56_130 VDD VSS sg13cmos5l_fill_2
XFILLER_45_826 VDD VSS sg13cmos5l_decap_8
XFILLER_57_697 VDD VSS sg13cmos5l_fill_2
XFILLER_72_645 VDD VSS sg13cmos5l_decap_4
XFILLER_44_347 VDD VSS sg13cmos5l_fill_1
XFILLER_45_859 VDD VSS sg13cmos5l_decap_8
XFILLER_72_689 VDD VSS sg13cmos5l_fill_1
XFILLER_71_155 VDD VSS sg13cmos5l_decap_8
Xbank_B_sram.gen_ihp_256x32.u_sram_256x32_489 bank_B_sram.gen_ihp_256x32.u_sram_256x32_489/L_LO
+ VDD VSS sg13cmos5l_tielo
Xbank_B_sram.gen_ihp_256x32.u_sram_256x32_478 bank_B_sram.gen_ihp_256x32.u_sram_256x32_478/L_LO
+ VDD VSS sg13cmos5l_tielo
XFILLER_60_75 VDD VSS sg13cmos5l_decap_8
XFILLER_5_15 VDD VSS sg13cmos5l_decap_8
XFILLER_79_233 VDD VSS sg13cmos5l_decap_8
XFILLER_67_439 VDD VSS sg13cmos5l_decap_8
XFILLER_48_642 VDD VSS sg13cmos5l_decap_8
XFILLER_36_837 VDD VSS sg13cmos5l_decap_8
XFILLER_75_483 VDD VSS sg13cmos5l_fill_1
XFILLER_35_336 VDD VSS sg13cmos5l_decap_4
XFILLER_47_174 VDD VSS sg13cmos5l_fill_2
XFILLER_62_100 VDD VSS sg13cmos5l_fill_1
XFILLER_62_122 VDD VSS sg13cmos5l_fill_2
XFILLER_63_656 VDD VSS sg13cmos5l_fill_2
X_3970_ _3970_/Y _3970_/A _3970_/B VDD VSS sg13cmos5l_nor2_1
X_5640_ _5694_/A _5588_/Y _5590_/A _5589_/A VDD VSS sg13cmos5l_a21oi_1
X_5571_ _5578_/A _5630_/A _5571_/B VDD VSS sg13cmos5l_xnor2_1
X_4522_ _4872_/A _4522_/A VDD VSS sg13cmos5l_buf_1
X_7310_ _7317_/A _7310_/A _7310_/B VDD VSS sg13cmos5l_nand2_2
X_4453_ _4454_/B _4453_/A _4453_/B VDD VSS sg13cmos5l_xor2_1
X_7241_ _7241_/Y _7241_/A _7290_/A VDD VSS sg13cmos5l_nor2_1
X_4384_ _4385_/B _4511_/A _4640_/A _4433_/A _4641_/A VDD VSS sg13cmos5l_a22oi_1
Xrebuffer1203 _5846_/A rebuffer1211/X VDD VSS sg13cmos5l_buf_1
Xrebuffer1214 rebuffer1214/X rebuffer1215/X VDD VSS sg13cmos5l_buf_1
Xrebuffer1225 rebuffer1225/X rebuffer1226/X VDD VSS sg13cmos5l_buf_1
X_7172_ _7172_/Y _7168_/Y _7169_/Y _7171_/Y _7205_/A _7327_/A VDD VSS sg13cmos5l_a221oi_1
Xrebuffer1247 rebuffer1247/X _6018_/A VDD VSS sg13cmos5l_buf_1
X_6123_ _6123_/Y _6089_/A _6123_/B VDD VSS sg13cmos5l_nand2b_1
Xrebuffer1236 _4548_/B_N _4547_/Y VDD VSS sg13cmos5l_buf_1
XFILLER_59_907 VDD VSS sg13cmos5l_decap_8
X_6054_ _6055_/A _6052_/B _6111_/A _6052_/Y _6053_/Y VDD VSS sg13cmos5l_a22oi_1
XFILLER_39_653 VDD VSS sg13cmos5l_decap_8
XFILLER_38_130 VDD VSS sg13cmos5l_decap_8
X_5005_ _5006_/B _5054_/A _5054_/B VDD VSS sg13cmos5l_xor2_1
XFILLER_54_645 VDD VSS sg13cmos5l_fill_1
XFILLER_81_464 VDD VSS sg13cmos5l_decap_8
XFILLER_42_807 VDD VSS sg13cmos5l_fill_2
XFILLER_53_155 VDD VSS sg13cmos5l_fill_2
X_6956_ _6956_/Y _6731_/X _6822_/X _6955_/Y VDD VSS sg13cmos5l_o21ai_1
X_5907_ _5957_/B _5907_/A _5947_/B VDD VSS sg13cmos5l_xnor2_1
X_6887_ _7101_/A _6943_/A _7032_/A _6886_/Y VDD VSS sg13cmos5l_o21ai_1
X_5838_ _5885_/A _5838_/A _5838_/B VDD VSS sg13cmos5l_and2_1
X_5769_ _5769_/Y _5769_/A _5718_/A VDD VSS sg13cmos5l_nor2b_1
X_7508_ _7620_/B _7508_/A _7508_/B VDD VSS sg13cmos5l_xor2_1
X_7439_ _7441_/B _7583_/B _7587_/A _7583_/A VDD VSS sg13cmos5l_nand3_1
XFILLER_77_715 VDD VSS sg13cmos5l_fill_1
XFILLER_39_43 VDD VSS sg13cmos5l_decap_8
XFILLER_49_428 VDD VSS sg13cmos5l_fill_2
XFILLER_49_417 VDD VSS sg13cmos5l_fill_2
XFILLER_76_258 VDD VSS sg13cmos5l_fill_2
XFILLER_73_932 VDD VSS sg13cmos5l_fill_2
XFILLER_72_431 VDD VSS sg13cmos5l_fill_2
XFILLER_57_483 VDD VSS sg13cmos5l_decap_8
XFILLER_57_494 VDD VSS sg13cmos5l_decap_4
XFILLER_44_133 VDD VSS sg13cmos5l_decap_4
XFILLER_45_689 VDD VSS sg13cmos5l_fill_2
XFILLER_60_604 VDD VSS sg13cmos5l_fill_1
XFILLER_72_497 VDD VSS sg13cmos5l_decap_4
XFILLER_44_177 VDD VSS sg13cmos5l_fill_1
XFILLER_41_862 VDD VSS sg13cmos5l_decap_4
XFILLER_68_737 VDD VSS sg13cmos5l_decap_8
XFILLER_67_225 VDD VSS sg13cmos5l_fill_2
XFILLER_76_781 VDD VSS sg13cmos5l_fill_1
XFILLER_36_601 VDD VSS sg13cmos5l_decap_8
XFILLER_36_612 VDD VSS sg13cmos5l_fill_2
XFILLER_36_667 VDD VSS sg13cmos5l_decap_4
X_6810_ _6834_/A _6797_/Y _6808_/Y _7076_/B VDD VSS sg13cmos5l_a21oi_1
X_3953_ _3968_/A _3953_/A _4422_/A _3953_/C VDD VSS sg13cmos5l_nand3_1
X_6741_ _6741_/Y _6740_/Y _6743_/A VDD VSS sg13cmos5l_nand2b_1
XFILLER_35_199 VDD VSS sg13cmos5l_fill_1
XFILLER_50_125 VDD VSS sg13cmos5l_fill_2
X_6672_ _6674_/A _6681_/C _6681_/A VDD VSS sg13cmos5l_xnor2_1
X_5623_ _5624_/B _5792_/B1 _5685_/A _5745_/B1 _5686_/A VDD VSS sg13cmos5l_a22oi_1
X_5554_ _5554_/Y _5554_/A _5499_/A VDD VSS sg13cmos5l_nor2b_1
X_5485_ _5489_/A _5485_/A _5485_/B VDD VSS sg13cmos5l_nand2_2
X_4505_ _4557_/A _4505_/A _4505_/B VDD VSS sg13cmos5l_xnor2_1
X_7224_ _7224_/Y _7280_/A1 _7369_/B _7223_/Y VDD VSS sg13cmos5l_o21ai_1
X_4436_ _4437_/B _4310_/X _4876_/A _4262_/X _4877_/A VDD VSS sg13cmos5l_a22oi_1
X_7155_ _7156_/B _7164_/A _7006_/A _7154_/Y VDD VSS sg13cmos5l_o21ai_1
X_4367_ _4368_/B _3965_/B _4563_/A _4203_/B _4564_/A VDD VSS sg13cmos5l_a22oi_1
X_6106_ _6152_/B _6095_/A _6095_/B _6096_/A VDD VSS sg13cmos5l_a21oi_1
XFILLER_59_759 VDD VSS sg13cmos5l_decap_8
X_7086_ _7086_/Y _7085_/B _6956_/Y _7085_/Y VDD VSS sg13cmos5l_o21ai_1
X_4298_ _4357_/A _4289_/B _4289_/A _4297_/X VDD VSS sg13cmos5l_a21o_1
X_6037_ _6037_/Y _6037_/A _6037_/B VDD VSS sg13cmos5l_nor2_1
XFILLER_92_18 VDD VSS sg13cmos5l_decap_8
XFILLER_82_773 VDD VSS sg13cmos5l_decap_4
XFILLER_81_261 VDD VSS sg13cmos5l_decap_8
X_6939_ _6939_/Y _6939_/A _6939_/B VDD VSS sg13cmos5l_nor2_1
XFILLER_50_692 VDD VSS sg13cmos5l_decap_8
XFILLER_50_681 VDD VSS sg13cmos5l_decap_8
XFILLER_41_66 VDD VSS sg13cmos5l_decap_8
XFILLER_66_41 VDD VSS sg13cmos5l_decap_8
XFILLER_46_932 VDD VSS sg13cmos5l_fill_2
XFILLER_73_762 VDD VSS sg13cmos5l_decap_4
XFILLER_41_681 VDD VSS sg13cmos5l_fill_2
XFILLER_41_692 VDD VSS sg13cmos5l_decap_8
XFILLER_56_4 VDD VSS sg13cmos5l_fill_2
Xoutput139 bank_A_rdata[30] _5457_/A VDD VSS sg13cmos5l_buf_1
Xoutput128 bank_A_rdata[20] _4823_/A VDD VSS sg13cmos5l_buf_1
Xoutput117 bank_A_rdata[10] _4216_/A VDD VSS sg13cmos5l_buf_1
X_5270_ _5271_/B _5382_/A _5756_/A2 _5859_/B1 _5756_/B2 VDD VSS sg13cmos5l_a22oi_1
X_4221_ _4269_/A _3957_/X _4511_/A _4220_/Y VDD VSS sg13cmos5l_a21o_1
XFILLER_68_523 VDD VSS sg13cmos5l_fill_2
X_4152_ _5944_/A _4875_/A VDD VSS sg13cmos5l_inv_1
Xbank_A_sram.gen_ihp_256x32.u_sram_256x32_580 bank_A_sram.gen_ihp_256x32.u_sram_256x32/A_DLY
+ VDD VSS sg13cmos5l_tiehi
X_4083_ _4375_/A _4083_/A VDD VSS sg13cmos5l_buf_8
XFILLER_37_921 VDD VSS sg13cmos5l_decap_8
XFILLER_37_932 VDD VSS sg13cmos5l_fill_2
XFILLER_64_740 VDD VSS sg13cmos5l_fill_2
X_4985_ _4993_/A _4923_/B _4854_/A _4985_/S VDD VSS sg13cmos5l_mux2_1
X_3936_ _3937_/A _3936_/A VDD VSS sg13cmos5l_buf_8
X_6724_ _6724_/X _6724_/A _6927_/B VDD VSS sg13cmos5l_and2_1
X_6655_ _6655_/Y _6656_/B _6656_/A VDD VSS sg13cmos5l_nor2_1
X_6586_ _6587_/A _6621_/A _6586_/B VDD VSS sg13cmos5l_nor2_1
X_5606_ _5608_/C _5606_/A _5606_/B VDD VSS sg13cmos5l_nand2_1
XFILLER_11_25 VDD VSS sg13cmos5l_decap_4
X_5537_ _5538_/A _5474_/B _5474_/A _5536_/Y VDD VSS sg13cmos5l_a21o_1
X_5468_ _5531_/B _5468_/A _5468_/B VDD VSS sg13cmos5l_xor2_1
X_7207_ _7207_/Y _6833_/B _7248_/A _7265_/A VDD VSS sg13cmos5l_a21oi_1
X_5399_ _5400_/B _5633_/A _5644_/A2 _5572_/A _5644_/B2 VDD VSS sg13cmos5l_a22oi_1
Xfanout300 _5080_/A _4771_/A VDD VSS sg13cmos5l_buf_1
Xfanout322 _5949_/B1 _5443_/X VDD VSS sg13cmos5l_buf_1
Xfanout311 _6941_/B _6970_/B VDD VSS sg13cmos5l_buf_1
X_4419_ _4421_/A _4494_/A _4492_/A VDD VSS sg13cmos5l_nand2b_1
Xfanout355 _5014_/A _3953_/C VDD VSS sg13cmos5l_buf_1
Xfanout333 _5302_/A _5225_/A VDD VSS sg13cmos5l_buf_1
X_7138_ _7138_/Y _7138_/A _7138_/B VDD VSS sg13cmos5l_nand2_1
XFILLER_59_556 VDD VSS sg13cmos5l_fill_2
Xfanout366 _5060_/A _4749_/A VDD VSS sg13cmos5l_buf_1
Xfanout344 _4986_/B1 _4433_/X VDD VSS sg13cmos5l_buf_1
Xfanout388 fanout388/X fanout392/X VDD VSS sg13cmos5l_buf_1
XFILLER_47_729 VDD VSS sg13cmos5l_fill_1
X_7069_ _7069_/Y _7069_/A _7071_/B VDD VSS sg13cmos5l_nand2_1
XFILLER_59_567 VDD VSS sg13cmos5l_fill_2
Xfanout377 _4508_/A _4432_/A VDD VSS sg13cmos5l_buf_1
XFILLER_39_280 VDD VSS sg13cmos5l_decap_8
XFILLER_36_11 VDD VSS sg13cmos5l_decap_8
XFILLER_74_559 VDD VSS sg13cmos5l_fill_1
XFILLER_36_22 VDD VSS sg13cmos5l_fill_1
XFILLER_36_88 VDD VSS sg13cmos5l_decap_8
XFILLER_55_773 VDD VSS sg13cmos5l_fill_1
Xinput19 input19/X bank_A_wdata[19] VDD VSS sg13cmos5l_buf_1
XFILLER_78_821 VDD VSS sg13cmos5l_decap_4
XFILLER_77_40 VDD VSS sg13cmos5l_fill_1
XFILLER_28_8 VDD VSS sg13cmos5l_decap_4
XFILLER_77_95 VDD VSS sg13cmos5l_decap_4
XFILLER_65_526 VDD VSS sg13cmos5l_fill_2
XFILLER_46_762 VDD VSS sg13cmos5l_fill_1
XFILLER_80_518 VDD VSS sg13cmos5l_decap_4
XFILLER_45_261 VDD VSS sg13cmos5l_fill_1
XFILLER_52_209 VDD VSS sg13cmos5l_decap_8
XFILLER_60_264 VDD VSS sg13cmos5l_decap_8
XFILLER_61_765 VDD VSS sg13cmos5l_decap_8
X_4770_ _4771_/B _5000_/A _4529_/X _4932_/A _4530_/X VDD VSS sg13cmos5l_a22oi_1
XFILLER_60_275 VDD VSS sg13cmos5l_fill_1
X_6440_ _6441_/A _6440_/A _6548_/D VDD VSS sg13cmos5l_nor2_1
X_6371_ _6373_/A _6372_/A _6372_/C _7669_/Q VDD VSS sg13cmos5l_a21oi_1
X_5322_ _5323_/B _5269_/A _5258_/A _5792_/B1 _5259_/A VDD VSS sg13cmos5l_a22oi_1
XFILLER_69_810 VDD VSS sg13cmos5l_decap_8
X_5253_ _5253_/Y _5253_/A _5213_/B VDD VSS sg13cmos5l_nor2b_1
XFILLER_68_331 VDD VSS sg13cmos5l_decap_8
X_5184_ _5185_/B _5184_/A _5240_/A VDD VSS sg13cmos5l_xnor2_1
X_4204_ _4255_/A _6022_/A _4204_/B VDD VSS sg13cmos5l_xnor2_1
X_4135_ _4136_/B _4135_/A _4182_/B VDD VSS sg13cmos5l_xor2_1
X_4066_ _4108_/C _4068_/B _4068_/A VDD VSS sg13cmos5l_xor2_1
XFILLER_64_592 VDD VSS sg13cmos5l_decap_8
XFILLER_51_242 VDD VSS sg13cmos5l_decap_4
X_4968_ _4970_/A _4968_/A _5302_/A VDD VSS sg13cmos5l_nand2_1
XFILLER_51_297 VDD VSS sg13cmos5l_fill_2
X_7687_ _7687_/Q clkload2/A _7687_/D fanout393/X VDD VSS sg13cmos5l_dfrbpq_1
XFILLER_22_24 VDD VSS sg13cmos5l_decap_4
X_6707_ _6780_/C _6779_/B VDD VSS sg13cmos5l_inv_1
X_4899_ _4963_/B _4958_/A _4899_/B VDD VSS sg13cmos5l_xnor2_1
X_6638_ _6647_/C _6671_/A _6638_/B VDD VSS sg13cmos5l_nand2_1
X_6569_ _6570_/B _6566_/Y _6579_/A _6527_/X VDD VSS sg13cmos5l_o21ai_1
XFILLER_59_331 VDD VSS sg13cmos5l_fill_2
XFILLER_75_846 VDD VSS sg13cmos5l_fill_2
XFILLER_74_312 VDD VSS sg13cmos5l_decap_8
XFILLER_47_32 VDD VSS sg13cmos5l_fill_2
XFILLER_47_515 VDD VSS sg13cmos5l_decap_8
Xfanout185 _6541_/A _6465_/A VDD VSS sg13cmos5l_buf_1
Xfanout196 _6027_/B2 _5686_/X VDD VSS sg13cmos5l_buf_1
XFILLER_59_375 VDD VSS sg13cmos5l_fill_2
XFILLER_75_879 VDD VSS sg13cmos5l_fill_2
XFILLER_75_868 VDD VSS sg13cmos5l_decap_8
XFILLER_47_559 VDD VSS sg13cmos5l_fill_1
XFILLER_43_732 VDD VSS sg13cmos5l_decap_8
XFILLER_63_31 VDD VSS sg13cmos5l_decap_8
XFILLER_42_242 VDD VSS sg13cmos5l_fill_1
XFILLER_8_26 VDD VSS sg13cmos5l_fill_2
XFILLER_69_139 VDD VSS sg13cmos5l_fill_1
XFILLER_69_128 VDD VSS sg13cmos5l_decap_8
XFILLER_66_835 VDD VSS sg13cmos5l_fill_2
XFILLER_80_304 VDD VSS sg13cmos5l_decap_8
X_5940_ _5960_/A _5916_/B _5916_/A _5939_/Y VDD VSS sg13cmos5l_a21oi_1
X_7610_ _7657_/A _7610_/A VDD VSS sg13cmos5l_buf_8
X_5871_ _5872_/B _5712_/X _5943_/A2 _5698_/X _5943_/B2 VDD VSS sg13cmos5l_a22oi_1
X_4822_ _5014_/B _4947_/B VDD VSS sg13cmos5l_buf_1
X_7541_ _7545_/C _7614_/B _7614_/A VDD VSS sg13cmos5l_or2_1
X_4753_ _4754_/B _5310_/B1 _5258_/A _4688_/X _5259_/A VDD VSS sg13cmos5l_a22oi_1
Xrebuffer719 _7534_/A1 _7245_/A VDD VSS sg13cmos5l_buf_1
Xrebuffer708 rebuffer708/X rebuffer709/X VDD VSS sg13cmos5l_buf_1
X_7472_ _7478_/B _7472_/A1 _7300_/Y _7472_/B1 VDD VSS sg13cmos5l_o21ai_1
X_4684_ _4684_/Y _4684_/A _4654_/B VDD VSS sg13cmos5l_nor2b_1
X_6423_ _6424_/A _6435_/B _6435_/A VDD VSS sg13cmos5l_nor2_1
X_6354_ _6947_/B _6354_/A VDD VSS sg13cmos5l_buf_1
X_6285_ _6286_/B _6285_/A _7661_/Q VDD VSS sg13cmos5l_xnor2_1
X_5305_ _5305_/Y _5305_/A _5305_/B VDD VSS sg13cmos5l_nor2_1
X_5236_ _7685_/D _5236_/A _5236_/B VDD VSS sg13cmos5l_xnor2_1
XFILLER_69_651 VDD VSS sg13cmos5l_fill_2
X_5167_ _5170_/A _5234_/B _5234_/A VDD VSS sg13cmos5l_xor2_1
X_4118_ _4153_/A _4207_/A _4118_/B VDD VSS sg13cmos5l_xnor2_1
X_5098_ _5109_/A _5110_/B _5110_/A VDD VSS sg13cmos5l_xor2_1
XFILLER_57_868 VDD VSS sg13cmos5l_fill_2
XFILLER_72_827 VDD VSS sg13cmos5l_decap_4
X_4049_ _4072_/A _4049_/A VDD VSS sg13cmos5l_inv_1
Xbank_B_sram.gen_ihp_256x32.u_sram_256x32_605 bank_B_sram.gen_ihp_256x32.u_sram_256x32_605/L_HI
+ VDD VSS sg13cmos5l_tiehi
XFILLER_17_24 VDD VSS sg13cmos5l_decap_4
XFILLER_72_849 VDD VSS sg13cmos5l_decap_8
XFILLER_40_724 VDD VSS sg13cmos5l_fill_1
XFILLER_33_23 VDD VSS sg13cmos5l_decap_4
XFILLER_52_595 VDD VSS sg13cmos5l_decap_8
XFILLER_58_53 VDD VSS sg13cmos5l_fill_2
XFILLER_75_621 VDD VSS sg13cmos5l_decap_8
XFILLER_58_86 VDD VSS sg13cmos5l_decap_8
XFILLER_75_665 VDD VSS sg13cmos5l_fill_2
XFILLER_47_334 VDD VSS sg13cmos5l_fill_2
XFILLER_63_805 VDD VSS sg13cmos5l_fill_2
XFILLER_47_367 VDD VSS sg13cmos5l_fill_2
XFILLER_47_389 VDD VSS sg13cmos5l_decap_4
XFILLER_74_197 VDD VSS sg13cmos5l_decap_8
XFILLER_74_63 VDD VSS sg13cmos5l_fill_2
XFILLER_62_326 VDD VSS sg13cmos5l_fill_1
XFILLER_95_8 VDD VSS sg13cmos5l_decap_8
XFILLER_71_893 VDD VSS sg13cmos5l_decap_8
XFILLER_43_595 VDD VSS sg13cmos5l_decap_8
Xwire372 wire372/X wire372/A VDD VSS sg13cmos5l_buf_4
X_6070_ _6100_/A _6070_/A _6097_/A VDD VSS sg13cmos5l_xnor2_1
X_5021_ _5022_/B _5058_/A _5021_/B VDD VSS sg13cmos5l_xnor2_1
XFILLER_65_120 VDD VSS sg13cmos5l_fill_2
XFILLER_65_131 VDD VSS sg13cmos5l_fill_1
XFILLER_81_624 VDD VSS sg13cmos5l_decap_8
XFILLER_66_676 VDD VSS sg13cmos5l_decap_4
XFILLER_54_838 VDD VSS sg13cmos5l_fill_1
Xclkbuf_4_11_0_clk_i_regs clkload6/A clkbuf_0_clk_i_regs/X VDD VSS sg13cmos5l_buf_8
XFILLER_80_101 VDD VSS sg13cmos5l_decap_8
X_6972_ _6972_/X _7082_/A _6972_/B VDD VSS sg13cmos5l_and2_1
X_5923_ _5923_/Y _5923_/A _5923_/B VDD VSS sg13cmos5l_nand2_1
XFILLER_80_178 VDD VSS sg13cmos5l_decap_8
X_5854_ _5854_/Y _5854_/A VDD VSS sg13cmos5l_inv_1
X_4805_ _4806_/B _4805_/A _4855_/A VDD VSS sg13cmos5l_xnor2_1
X_7524_ _7526_/A _7524_/A _7524_/B VDD VSS sg13cmos5l_nand2_1
X_5785_ _5787_/A _5785_/A1 _5786_/B _5786_/C VDD VSS sg13cmos5l_a21oi_1
X_4736_ _4745_/A _4679_/B _4854_/A _4736_/S VDD VSS sg13cmos5l_mux2_1
X_7455_ _7491_/A _7461_/A _7456_/A VDD VSS sg13cmos5l_nand2b_1
X_4667_ _4727_/B _4726_/B _4726_/A VDD VSS sg13cmos5l_xor2_1
X_7386_ _7389_/A _7386_/A _7509_/B _7510_/B VDD VSS sg13cmos5l_nand3_1
X_6406_ _6823_/B _6406_/A _6406_/B VDD VSS sg13cmos5l_nand2_2
X_6337_ _6339_/A _6338_/A _6391_/A _7666_/Q VDD VSS sg13cmos5l_a21oi_1
X_4598_ _4598_/Y _4598_/A VDD VSS sg13cmos5l_inv_1
Xbank_A_sram.gen_ihp_256x32.u_sram_256x32_409 bank_A_sram.gen_ihp_256x32.u_sram_256x32_409/L_LO
+ VDD VSS sg13cmos5l_tielo
X_6268_ _6269_/A _6268_/A _6268_/B _6704_/A VDD VSS sg13cmos5l_nand3_1
X_6199_ _6199_/Y _6223_/A _6199_/B VDD VSS sg13cmos5l_nor2_1
X_5219_ _5238_/A _5219_/A _5219_/B VDD VSS sg13cmos5l_nand2_1
XFILLER_57_643 VDD VSS sg13cmos5l_fill_2
XFILLER_60_819 VDD VSS sg13cmos5l_fill_1
Xbank_B_sram.gen_ihp_256x32.u_sram_256x32_479 bank_B_sram.gen_ihp_256x32.u_sram_256x32_479/L_LO
+ VDD VSS sg13cmos5l_tielo
XFILLER_40_532 VDD VSS sg13cmos5l_decap_4
XFILLER_60_43 VDD VSS sg13cmos5l_decap_4
XFILLER_79_212 VDD VSS sg13cmos5l_decap_8
XFILLER_79_289 VDD VSS sg13cmos5l_decap_8
XFILLER_75_440 VDD VSS sg13cmos5l_decap_4
XFILLER_75_462 VDD VSS sg13cmos5l_decap_8
XFILLER_35_359 VDD VSS sg13cmos5l_decap_4
XFILLER_62_145 VDD VSS sg13cmos5l_fill_2
XFILLER_50_318 VDD VSS sg13cmos5l_fill_1
XFILLER_43_381 VDD VSS sg13cmos5l_decap_4
XFILLER_86_4 VDD VSS sg13cmos5l_decap_8
X_5570_ _5571_/B _5859_/B1 _5941_/A2 _5792_/B1 _5941_/B2 VDD VSS sg13cmos5l_a22oi_1
X_4521_ _4534_/A _4761_/A _4521_/B VDD VSS sg13cmos5l_xnor2_1
X_4452_ _4453_/B _4518_/A _4518_/B VDD VSS sg13cmos5l_xor2_1
X_7240_ _7241_/A _7289_/A _7376_/B _7239_/Y VDD VSS sg13cmos5l_o21ai_1
Xrebuffer1204 _4111_/B _4093_/A VDD VSS sg13cmos5l_buf_1
X_4383_ _4397_/A _4333_/B _4333_/A _4382_/Y VDD VSS sg13cmos5l_a21oi_1
Xrebuffer1215 rebuffer1215/X rebuffer1216/X VDD VSS sg13cmos5l_buf_1
Xrebuffer1226 rebuffer1226/X _5848_/A VDD VSS sg13cmos5l_buf_1
X_7171_ _7171_/Y _7191_/B _7013_/Y _7170_/Y VDD VSS sg13cmos5l_o21ai_1
Xrebuffer1237 rebuffer1237/X rebuffer1238/X VDD VSS sg13cmos5l_buf_1
Xrebuffer1248 _5888_/A1 _5889_/A VDD VSS sg13cmos5l_buf_1
X_6122_ _6135_/B _6144_/A _6122_/B VDD VSS sg13cmos5l_xnor2_1
XFILLER_59_919 VDD VSS sg13cmos5l_decap_8
XFILLER_58_429 VDD VSS sg13cmos5l_fill_2
X_6053_ _6053_/Y _6111_/A _6053_/B VDD VSS sg13cmos5l_nor2_1
XFILLER_67_930 VDD VSS sg13cmos5l_decap_4
X_5004_ _5054_/B _5446_/A _5004_/B VDD VSS sg13cmos5l_xnor2_1
XFILLER_82_933 VDD VSS sg13cmos5l_fill_1
XFILLER_66_484 VDD VSS sg13cmos5l_decap_4
XFILLER_38_186 VDD VSS sg13cmos5l_decap_8
XFILLER_53_123 VDD VSS sg13cmos5l_decap_8
XFILLER_81_443 VDD VSS sg13cmos5l_decap_8
X_6955_ _6955_/Y _6955_/A _6955_/B VDD VSS sg13cmos5l_nand2_1
XFILLER_81_498 VDD VSS sg13cmos5l_decap_8
XFILLER_35_871 VDD VSS sg13cmos5l_fill_1
XFILLER_53_178 VDD VSS sg13cmos5l_decap_4
X_5906_ _5947_/B _5906_/A _5906_/B VDD VSS sg13cmos5l_xnor2_1
XFILLER_14_25 VDD VSS sg13cmos5l_decap_4
XFILLER_50_841 VDD VSS sg13cmos5l_decap_8
X_6886_ _6886_/Y _6886_/A _6943_/A VDD VSS sg13cmos5l_nand2_1
X_5837_ _5838_/B _5837_/A _5837_/B _5837_/C VDD VSS sg13cmos5l_nand3_1
XFILLER_50_885 VDD VSS sg13cmos5l_decap_8
X_5768_ _5822_/A _5768_/A _5768_/B VDD VSS sg13cmos5l_xnor2_1
X_7507_ _7508_/B _7564_/B _7507_/B VDD VSS sg13cmos5l_nand2_1
X_4719_ _4730_/A _4660_/B _4660_/A _4718_/Y VDD VSS sg13cmos5l_a21o_1
X_5699_ _5700_/B _6082_/B1 _5869_/A2 _6058_/B1 _5869_/B2 VDD VSS sg13cmos5l_a22oi_1
XFILLER_30_24 VDD VSS sg13cmos5l_decap_4
X_7438_ _7583_/A _7456_/A _7585_/B VDD VSS sg13cmos5l_xnor2_1
X_7369_ _7370_/A _7404_/A _7369_/B VDD VSS sg13cmos5l_nor2_1
XFILLER_39_22 VDD VSS sg13cmos5l_decap_8
XFILLER_76_237 VDD VSS sg13cmos5l_decap_8
XFILLER_39_99 VDD VSS sg13cmos5l_decap_8
XFILLER_44_112 VDD VSS sg13cmos5l_fill_1
XFILLER_72_465 VDD VSS sg13cmos5l_decap_4
XFILLER_45_668 VDD VSS sg13cmos5l_decap_4
XFILLER_68_716 VDD VSS sg13cmos5l_decap_8
XFILLER_76_760 VDD VSS sg13cmos5l_fill_1
XFILLER_82_218 VDD VSS sg13cmos5l_decap_4
XFILLER_36_624 VDD VSS sg13cmos5l_fill_1
XFILLER_35_101 VDD VSS sg13cmos5l_decap_4
XFILLER_63_421 VDD VSS sg13cmos5l_decap_8
XFILLER_35_134 VDD VSS sg13cmos5l_decap_4
XFILLER_51_605 VDD VSS sg13cmos5l_decap_8
XFILLER_63_454 VDD VSS sg13cmos5l_decap_8
X_6740_ _6740_/Y _6740_/A1 _6733_/B _6661_/B VDD VSS sg13cmos5l_a21oi_1
X_3952_ _4422_/A _3999_/B VDD VSS sg13cmos5l_inv_1
XFILLER_44_690 VDD VSS sg13cmos5l_fill_1
X_6671_ _6681_/C _6671_/A _6671_/B VDD VSS sg13cmos5l_nand2_1
X_5622_ _5682_/S _5684_/B1 _5858_/A _5622_/B1 _5683_/A VDD VSS sg13cmos5l_a22oi_1
XFILLER_77_0 VDD VSS sg13cmos5l_fill_2
X_5553_ _7690_/D _5553_/A _5618_/A VDD VSS sg13cmos5l_nor2b_2
X_4504_ _4505_/B _4502_/Y _4504_/B VDD VSS sg13cmos5l_nand2b_1
X_5484_ _5488_/A _5489_/C _5552_/B VDD VSS sg13cmos5l_nand2_1
X_7223_ _7223_/Y _7179_/X _6953_/A _7222_/Y VDD VSS sg13cmos5l_o21ai_1
X_4435_ _4500_/A _4871_/A _4435_/B VDD VSS sg13cmos5l_xnor2_1
XFILLER_116_27 VDD VSS sg13cmos5l_fill_2
XFILLER_116_16 VDD VSS sg13cmos5l_decap_8
X_7154_ _7154_/Y _7154_/A _7164_/A VDD VSS sg13cmos5l_nand2_1
X_4366_ _4564_/A _4366_/A VDD VSS sg13cmos5l_buf_1
X_6105_ _7702_/D _6105_/A _6105_/B VDD VSS sg13cmos5l_xor2_1
XFILLER_58_204 VDD VSS sg13cmos5l_decap_8
X_7085_ _7085_/Y _7085_/A _7085_/B VDD VSS sg13cmos5l_nand2_1
X_4297_ _4297_/X _4297_/A _4297_/B VDD VSS sg13cmos5l_and2_1
XFILLER_73_207 VDD VSS sg13cmos5l_fill_2
X_6036_ _6036_/Y _6036_/A VDD VSS sg13cmos5l_inv_1
XFILLER_58_259 VDD VSS sg13cmos5l_fill_1
XFILLER_82_730 VDD VSS sg13cmos5l_fill_1
XFILLER_55_933 VDD VSS sg13cmos5l_fill_1
XFILLER_55_922 VDD VSS sg13cmos5l_decap_8
XFILLER_82_763 VDD VSS sg13cmos5l_decap_4
XFILLER_81_240 VDD VSS sg13cmos5l_decap_8
XFILLER_66_292 VDD VSS sg13cmos5l_decap_4
XFILLER_42_638 VDD VSS sg13cmos5l_decap_8
XFILLER_42_649 VDD VSS sg13cmos5l_fill_1
XFILLER_41_115 VDD VSS sg13cmos5l_decap_8
X_6938_ _6938_/Y _6932_/Y _7036_/A _6937_/Y VDD VSS sg13cmos5l_a21oi_2
X_6869_ _6871_/A _6869_/A _6869_/B VDD VSS sg13cmos5l_nand2_1
XFILLER_41_12 VDD VSS sg13cmos5l_decap_4
XFILLER_77_524 VDD VSS sg13cmos5l_decap_8
XFILLER_2_28 VDD VSS sg13cmos5l_fill_1
XFILLER_49_215 VDD VSS sg13cmos5l_decap_4
XFILLER_49_237 VDD VSS sg13cmos5l_decap_8
XFILLER_77_579 VDD VSS sg13cmos5l_fill_1
XFILLER_57_281 VDD VSS sg13cmos5l_decap_8
XFILLER_72_240 VDD VSS sg13cmos5l_fill_1
XFILLER_82_30 VDD VSS sg13cmos5l_decap_8
XFILLER_72_251 VDD VSS sg13cmos5l_decap_4
XFILLER_82_52 VDD VSS sg13cmos5l_decap_8
XFILLER_60_435 VDD VSS sg13cmos5l_fill_1
Xoutput129 bank_A_rdata[21] _4886_/A VDD VSS sg13cmos5l_buf_1
Xoutput118 bank_A_rdata[11] _4273_/A VDD VSS sg13cmos5l_buf_1
X_4220_ _4220_/Y _4220_/A _4220_/B VDD VSS sg13cmos5l_nor2_1
XFILLER_68_502 VDD VSS sg13cmos5l_fill_2
XFILLER_68_546 VDD VSS sg13cmos5l_decap_8
X_4151_ _4578_/A _4266_/A VDD VSS sg13cmos5l_buf_1
Xbank_A_sram.gen_ihp_256x32.u_sram_256x32_581 bank_A_sram.gen_ihp_256x32.u_sram_256x32/A_MEN
+ VDD VSS sg13cmos5l_tiehi
Xbank_A_sram.gen_ihp_256x32.u_sram_256x32_570 bank_A_sram.gen_ihp_256x32.u_sram_256x32_570/L_HI
+ VDD VSS sg13cmos5l_tiehi
X_4082_ _4092_/A _4168_/A _4082_/B VDD VSS sg13cmos5l_xnor2_1
XFILLER_37_900 VDD VSS sg13cmos5l_decap_8
XFILLER_49_771 VDD VSS sg13cmos5l_decap_8
XFILLER_49_793 VDD VSS sg13cmos5l_fill_2
XFILLER_102_18 VDD VSS sg13cmos5l_decap_8
XFILLER_48_281 VDD VSS sg13cmos5l_fill_2
XFILLER_64_763 VDD VSS sg13cmos5l_fill_1
X_4984_ _5029_/A _4984_/A _5045_/B VDD VSS sg13cmos5l_xnor2_1
X_3935_ _7659_/D _3935_/A VDD VSS sg13cmos5l_inv_1
X_6723_ _6724_/A _6722_/Y _6723_/B VDD VSS sg13cmos5l_nand2b_1
X_6654_ _6656_/B _6671_/A _6654_/B VDD VSS sg13cmos5l_nand2_1
X_5605_ _5608_/A _5667_/B VDD VSS sg13cmos5l_inv_1
X_6585_ _6592_/A _6585_/A _6585_/B VDD VSS sg13cmos5l_nand2_2
X_5536_ _5536_/Y _5536_/A _5475_/B VDD VSS sg13cmos5l_nor2b_1
X_5467_ _5468_/B _5501_/A _5467_/B VDD VSS sg13cmos5l_xnor2_1
X_7206_ _7362_/B _6776_/X _7205_/A _7205_/Y VDD VSS sg13cmos5l_a21oi_1
X_4418_ _4483_/A _4418_/A _4418_/B VDD VSS sg13cmos5l_and2_1
Xfanout301 _4944_/A _4387_/X VDD VSS sg13cmos5l_buf_1
X_5398_ _5453_/A _5460_/B _5698_/A _5397_/Y VDD VSS sg13cmos5l_a21o_1
Xfanout312 _6909_/B _6981_/A VDD VSS sg13cmos5l_buf_1
Xfanout323 _5909_/B1 _5382_/X VDD VSS sg13cmos5l_buf_1
Xfanout356 _3965_/B _3937_/X VDD VSS sg13cmos5l_buf_2
X_7137_ _7137_/Y _7294_/A _7051_/X _7136_/X VDD VSS sg13cmos5l_a21oi_1
XFILLER_59_535 VDD VSS sg13cmos5l_fill_2
Xfanout334 _5493_/B1 _4932_/X VDD VSS sg13cmos5l_buf_1
Xfanout345 _4920_/B1 _4375_/X VDD VSS sg13cmos5l_buf_1
X_4349_ _4353_/A _4411_/B _4349_/B VDD VSS sg13cmos5l_xnor2_1
XFILLER_74_505 VDD VSS sg13cmos5l_decap_8
Xfanout389 fanout389/X fanout390/X VDD VSS sg13cmos5l_buf_1
X_7068_ _7068_/Y _7063_/Y _7108_/S _7067_/Y VDD VSS sg13cmos5l_a21oi_1
Xfanout367 _4875_/A _4578_/A VDD VSS sg13cmos5l_buf_1
Xfanout378 _4266_/A _4316_/A VDD VSS sg13cmos5l_buf_1
X_6019_ _6019_/Y _6019_/A _5992_/A VDD VSS sg13cmos5l_nor2b_1
XFILLER_67_590 VDD VSS sg13cmos5l_fill_2
XFILLER_55_741 VDD VSS sg13cmos5l_decap_4
XFILLER_70_711 VDD VSS sg13cmos5l_fill_1
XFILLER_36_67 VDD VSS sg13cmos5l_decap_8
XFILLER_42_435 VDD VSS sg13cmos5l_fill_2
XFILLER_70_799 VDD VSS sg13cmos5l_decap_4
XFILLER_52_88 VDD VSS sg13cmos5l_decap_4
XFILLER_77_321 VDD VSS sg13cmos5l_decap_4
XFILLER_77_354 VDD VSS sg13cmos5l_decap_8
XFILLER_37_207 VDD VSS sg13cmos5l_decap_8
XFILLER_73_560 VDD VSS sg13cmos5l_fill_2
XFILLER_45_240 VDD VSS sg13cmos5l_fill_1
XFILLER_46_774 VDD VSS sg13cmos5l_decap_4
XFILLER_73_582 VDD VSS sg13cmos5l_decap_8
XFILLER_61_777 VDD VSS sg13cmos5l_decap_4
XFILLER_61_799 VDD VSS sg13cmos5l_decap_4
X_6370_ _6372_/A _6367_/Y _6379_/A VDD VSS sg13cmos5l_nand2b_1
X_5321_ _5327_/A _5321_/A _5321_/B VDD VSS sg13cmos5l_xnor2_1
X_5252_ _5346_/A _5252_/A _5252_/B VDD VSS sg13cmos5l_xor2_1
XFILLER_69_855 VDD VSS sg13cmos5l_fill_2
XFILLER_69_844 VDD VSS sg13cmos5l_fill_2
XFILLER_69_822 VDD VSS sg13cmos5l_fill_2
X_5183_ _5240_/A _5137_/B _5137_/A _5182_/X VDD VSS sg13cmos5l_a21oi_1
X_4203_ _4204_/B _4429_/A _4203_/B VDD VSS sg13cmos5l_nand2_1
X_4134_ _4182_/B _4134_/A _4134_/B VDD VSS sg13cmos5l_xor2_1
X_4065_ _4068_/B _4072_/A _4065_/B VDD VSS sg13cmos5l_xnor2_1
XFILLER_36_284 VDD VSS sg13cmos5l_decap_8
XFILLER_52_722 VDD VSS sg13cmos5l_fill_2
XFILLER_40_917 VDD VSS sg13cmos5l_decap_8
X_4967_ _5225_/A _4984_/A VDD VSS sg13cmos5l_buf_1
XFILLER_51_287 VDD VSS sg13cmos5l_fill_2
X_7686_ _7686_/Q _7704_/CLK _7686_/D fanout393/X VDD VSS sg13cmos5l_dfrbpq_1
X_6706_ _6779_/B _6696_/Y _6702_/Y _6705_/Y VDD VSS sg13cmos5l_a21oi_1
X_4898_ _4899_/B _4898_/A _4959_/B VDD VSS sg13cmos5l_xor2_1
X_6637_ _6732_/B _6637_/A _6637_/B VDD VSS sg13cmos5l_nand2_2
X_6568_ _6579_/A _6568_/A VDD VSS sg13cmos5l_buf_2
XFILLER_98_18 VDD VSS sg13cmos5l_decap_8
X_5519_ _5520_/A _5519_/A _5519_/B VDD VSS sg13cmos5l_nand2_1
X_6499_ _6508_/B _6541_/A _6979_/B _6909_/B _6978_/B VDD VSS sg13cmos5l_nand4_1
XFILLER_78_129 VDD VSS sg13cmos5l_decap_8
XFILLER_59_354 VDD VSS sg13cmos5l_fill_2
XFILLER_75_836 VDD VSS sg13cmos5l_fill_2
Xfanout197 _5941_/B2 _5569_/X VDD VSS sg13cmos5l_buf_1
XFILLER_47_44 VDD VSS sg13cmos5l_fill_2
Xfanout186 _6621_/A _6408_/A VDD VSS sg13cmos5l_buf_1
XFILLER_47_66 VDD VSS sg13cmos5l_fill_1
XFILLER_63_98 VDD VSS sg13cmos5l_fill_2
XFILLER_69_107 VDD VSS sg13cmos5l_decap_8
XFILLER_40_8 VDD VSS sg13cmos5l_decap_8
XFILLER_65_346 VDD VSS sg13cmos5l_decap_8
XFILLER_65_357 VDD VSS sg13cmos5l_decap_8
X_5870_ _5913_/A _5870_/A _5870_/B VDD VSS sg13cmos5l_xnor2_1
X_4821_ _4832_/A _5331_/A _4821_/B VDD VSS sg13cmos5l_xnor2_1
XFILLER_61_563 VDD VSS sg13cmos5l_decap_8
X_7540_ _7614_/A _7539_/Y _7540_/B VDD VSS sg13cmos5l_nand2b_1
X_4752_ _4752_/X _4752_/A VDD VSS sg13cmos5l_buf_1
X_7471_ _7477_/B _7471_/A VDD VSS sg13cmos5l_buf_1
Xrebuffer709 rebuffer709/X rebuffer710/X VDD VSS sg13cmos5l_buf_1
X_4683_ _4778_/B _4683_/A _4683_/B VDD VSS sg13cmos5l_xor2_1
X_6422_ _6435_/A _6431_/A _6421_/Y _6461_/C VDD VSS sg13cmos5l_o21ai_1
X_6353_ _7189_/A _6353_/A VDD VSS sg13cmos5l_buf_1
X_6284_ _6285_/A _6284_/A _6317_/C VDD VSS sg13cmos5l_nand2_2
X_5304_ _5363_/B _5418_/A _5304_/B VDD VSS sg13cmos5l_nor2_1
X_5235_ _5298_/A _5169_/Y _5170_/A _5234_/X VDD VSS sg13cmos5l_a21o_1
X_5166_ _5234_/A _5228_/A _5229_/A VDD VSS sg13cmos5l_xor2_1
X_4117_ _4118_/B _3963_/A _4047_/A _3937_/A _4076_/A VDD VSS sg13cmos5l_a22oi_1
X_5097_ _5110_/A _5029_/B _5029_/A _5096_/X VDD VSS sg13cmos5l_a21o_1
X_4048_ _4049_/A _4751_/A _4203_/B VDD VSS sg13cmos5l_nand2_1
Xbank_B_sram.gen_ihp_256x32.u_sram_256x32_606 bank_B_sram.gen_ihp_256x32.u_sram_256x32_606/L_HI
+ VDD VSS sg13cmos5l_tiehi
XFILLER_56_379 VDD VSS sg13cmos5l_fill_1
X_5999_ _5999_/Y _5999_/A _5999_/B VDD VSS sg13cmos5l_nand2_1
XFILLER_40_747 VDD VSS sg13cmos5l_decap_4
X_7669_ _7669_/Q clkload8/A _7669_/D fanout389/X VDD VSS sg13cmos5l_dfrbpq_1
XFILLER_47_313 VDD VSS sg13cmos5l_fill_1
XFILLER_74_154 VDD VSS sg13cmos5l_fill_2
XFILLER_74_31 VDD VSS sg13cmos5l_decap_4
XFILLER_74_97 VDD VSS sg13cmos5l_decap_4
XFILLER_43_541 VDD VSS sg13cmos5l_decap_8
Xwire373 _3936_/A wire373/A VDD VSS sg13cmos5l_buf_8
X_5020_ _5021_/B _5020_/A _5020_/B VDD VSS sg13cmos5l_xor2_1
XFILLER_31_4 VDD VSS sg13cmos5l_fill_2
XFILLER_38_335 VDD VSS sg13cmos5l_fill_1
XFILLER_81_603 VDD VSS sg13cmos5l_decap_8
XFILLER_38_357 VDD VSS sg13cmos5l_decap_8
XFILLER_53_305 VDD VSS sg13cmos5l_fill_1
XFILLER_54_806 VDD VSS sg13cmos5l_decap_8
X_6971_ _7082_/A _6974_/B _6788_/A _6970_/Y VDD VSS sg13cmos5l_o21ai_1
XFILLER_65_187 VDD VSS sg13cmos5l_decap_8
XFILLER_80_157 VDD VSS sg13cmos5l_decap_8
X_5922_ _5922_/Y _5922_/A VDD VSS sg13cmos5l_inv_1
XFILLER_53_349 VDD VSS sg13cmos5l_decap_4
XFILLER_110_18 VDD VSS sg13cmos5l_decap_8
X_5853_ _5881_/A _5800_/B _5800_/A _5852_/Y VDD VSS sg13cmos5l_a21oi_1
XFILLER_61_371 VDD VSS sg13cmos5l_decap_8
XFILLER_62_872 VDD VSS sg13cmos5l_fill_1
X_5784_ _5786_/C _5845_/B _5845_/A VDD VSS sg13cmos5l_xor2_1
X_4804_ _4855_/A _4758_/B _4758_/A _4803_/X VDD VSS sg13cmos5l_a21oi_1
X_7523_ _7618_/D _7523_/A _7519_/A VDD VSS sg13cmos5l_nor2b_1
X_4735_ _4794_/A _4683_/B _4683_/A _4734_/Y VDD VSS sg13cmos5l_a21oi_1
X_7454_ _7461_/A _7226_/Y _7397_/A _7399_/A VDD VSS sg13cmos5l_a21o_1
X_4666_ _4726_/A _4671_/A _4671_/B VDD VSS sg13cmos5l_xor2_1
X_7385_ _7510_/B _7385_/A _7387_/A VDD VSS sg13cmos5l_nand2_1
X_4597_ _4658_/B _4597_/A _4597_/B VDD VSS sg13cmos5l_xor2_1
X_6405_ _6406_/B _6403_/B _7672_/Q VDD VSS sg13cmos5l_nand2b_1
X_6336_ _6338_/A _6336_/A _6342_/B VDD VSS sg13cmos5l_xor2_1
X_6267_ _6270_/A _6267_/A _6267_/B VDD VSS sg13cmos5l_nand2_1
X_6198_ _6198_/Y _6198_/A VDD VSS sg13cmos5l_inv_1
X_5218_ _5219_/B _5155_/A _5218_/B VDD VSS sg13cmos5l_nand2b_1
X_5149_ _5150_/B _5382_/A _5644_/A2 _5269_/A _5644_/B2 VDD VSS sg13cmos5l_a22oi_1
XFILLER_56_154 VDD VSS sg13cmos5l_fill_2
XFILLER_71_102 VDD VSS sg13cmos5l_decap_4
XFILLER_56_176 VDD VSS sg13cmos5l_fill_2
XFILLER_72_658 VDD VSS sg13cmos5l_fill_1
XFILLER_53_872 VDD VSS sg13cmos5l_fill_1
XFILLER_60_22 VDD VSS sg13cmos5l_decap_8
XFILLER_40_599 VDD VSS sg13cmos5l_fill_2
XFILLER_69_53 VDD VSS sg13cmos5l_fill_2
XFILLER_79_268 VDD VSS sg13cmos5l_decap_8
XFILLER_47_110 VDD VSS sg13cmos5l_fill_2
XFILLER_35_316 VDD VSS sg13cmos5l_fill_1
XFILLER_47_176 VDD VSS sg13cmos5l_fill_1
XFILLER_63_636 VDD VSS sg13cmos5l_decap_8
XFILLER_62_168 VDD VSS sg13cmos5l_fill_2
X_4520_ _4521_/B _4631_/A _4640_/A _4574_/A _4641_/A VDD VSS sg13cmos5l_a22oi_1
X_4451_ _4518_/B _4528_/A _4451_/B VDD VSS sg13cmos5l_xnor2_1
X_7170_ _7170_/Y _7170_/A _7191_/B VDD VSS sg13cmos5l_nand2_1
X_4382_ _4382_/Y _4382_/A _4382_/B VDD VSS sg13cmos5l_nor2_1
Xrebuffer1205 _5039_/B _5105_/A VDD VSS sg13cmos5l_buf_1
Xrebuffer1216 rebuffer1216/X rebuffer1217/X VDD VSS sg13cmos5l_buf_1
X_6121_ _6122_/B _6145_/A _6145_/B VDD VSS sg13cmos5l_xor2_1
Xrebuffer1238 rebuffer1238/X rebuffer1239/X VDD VSS sg13cmos5l_buf_1
Xrebuffer1227 _5423_/B _5485_/A VDD VSS sg13cmos5l_buf_1
XFILLER_105_18 VDD VSS sg13cmos5l_decap_8
XFILLER_39_611 VDD VSS sg13cmos5l_fill_2
X_6052_ _6052_/Y _6052_/A _6052_/B VDD VSS sg13cmos5l_nand2_1
XFILLER_78_290 VDD VSS sg13cmos5l_decap_8
XFILLER_66_430 VDD VSS sg13cmos5l_fill_2
X_5003_ _5004_/B _5430_/B1 _5447_/A _5370_/B1 _5448_/A VDD VSS sg13cmos5l_a22oi_1
XFILLER_81_422 VDD VSS sg13cmos5l_decap_8
XFILLER_39_688 VDD VSS sg13cmos5l_decap_8
XFILLER_38_165 VDD VSS sg13cmos5l_decap_8
XFILLER_53_157 VDD VSS sg13cmos5l_fill_1
X_6954_ _7319_/B _6938_/Y _6909_/B _6953_/X VDD VSS sg13cmos5l_a21oi_2
XFILLER_35_894 VDD VSS sg13cmos5l_fill_1
X_5905_ _5906_/B _5903_/Y _5905_/B VDD VSS sg13cmos5l_nand2b_1
X_6885_ _6886_/A _6960_/B _6882_/Y _6884_/Y VDD VSS sg13cmos5l_o21ai_1
XFILLER_62_680 VDD VSS sg13cmos5l_fill_1
X_5836_ _5838_/A _5837_/B _5837_/C _5837_/A VDD VSS sg13cmos5l_a21o_1
XFILLER_50_864 VDD VSS sg13cmos5l_decap_8
X_5767_ _5768_/B _5767_/A _5767_/B VDD VSS sg13cmos5l_xor2_1
X_7506_ _7508_/A _7506_/A _7506_/B VDD VSS sg13cmos5l_nand2_1
X_5698_ _5698_/X _5698_/A VDD VSS sg13cmos5l_buf_1
X_4718_ _4718_/Y _4718_/A _4661_/B VDD VSS sg13cmos5l_nor2b_1
X_4649_ _4695_/A _4947_/B _4932_/A _4648_/Y VDD VSS sg13cmos5l_a21o_1
X_7437_ _7585_/B _7472_/A1 _7437_/A2 _7472_/B1 VDD VSS sg13cmos5l_o21ai_1
XFILLER_100_7 VDD VSS sg13cmos5l_decap_8
X_7368_ _7375_/A _7368_/A _7368_/B _7513_/A VDD VSS sg13cmos5l_nand3_1
X_6319_ _6320_/A _6787_/B _6787_/A VDD VSS sg13cmos5l_nand2_2
X_7299_ _7299_/Y _7158_/X _7295_/Y _7298_/Y VDD VSS sg13cmos5l_o21ai_1
XFILLER_76_227 VDD VSS sg13cmos5l_decap_4
XFILLER_39_78 VDD VSS sg13cmos5l_decap_8
XFILLER_45_603 VDD VSS sg13cmos5l_fill_2
XFILLER_72_455 VDD VSS sg13cmos5l_decap_8
XFILLER_72_488 VDD VSS sg13cmos5l_fill_1
XFILLER_41_853 VDD VSS sg13cmos5l_fill_2
XFILLER_49_920 VDD VSS sg13cmos5l_fill_2
XFILLER_82_208 VDD VSS sg13cmos5l_fill_2
XFILLER_48_430 VDD VSS sg13cmos5l_decap_8
XFILLER_64_923 VDD VSS sg13cmos5l_decap_8
XFILLER_36_658 VDD VSS sg13cmos5l_fill_1
X_3951_ _3970_/A _4529_/A _4203_/B VDD VSS sg13cmos5l_nand2_2
XFILLER_35_157 VDD VSS sg13cmos5l_decap_8
XFILLER_51_628 VDD VSS sg13cmos5l_fill_2
XFILLER_63_477 VDD VSS sg13cmos5l_decap_4
XFILLER_44_680 VDD VSS sg13cmos5l_fill_2
XFILLER_50_127 VDD VSS sg13cmos5l_fill_1
X_6670_ _6677_/A _6670_/A _6742_/A _6743_/B VDD VSS sg13cmos5l_nand3_1
X_5621_ _5629_/A _5560_/B _5302_/A _5621_/S VDD VSS sg13cmos5l_mux2_1
X_5552_ _5618_/A _5552_/A _5552_/B _5552_/C VDD VSS sg13cmos5l_nand3_1
X_4503_ _4504_/B _4503_/A _4503_/B VDD VSS sg13cmos5l_nand2_1
X_5483_ _5552_/B _5482_/B _5483_/B VDD VSS sg13cmos5l_nand2b_1
X_7222_ _7222_/Y _7265_/A _7222_/B VDD VSS sg13cmos5l_nor2_1
X_4434_ _4435_/B _4986_/B1 _4751_/A _4920_/B1 _4076_/X VDD VSS sg13cmos5l_a22oi_1
X_7153_ _7218_/A _7153_/A VDD VSS sg13cmos5l_buf_1
X_4365_ _4366_/A _4621_/A _6110_/A _4364_/Y VDD VSS sg13cmos5l_o21ai_1
X_6104_ _6105_/B _6078_/B _6078_/A _6103_/X VDD VSS sg13cmos5l_a21o_1
XFILLER_59_717 VDD VSS sg13cmos5l_fill_1
X_7084_ _7084_/Y _7082_/Y _7083_/Y _6809_/X VDD VSS sg13cmos5l_a21oi_1
X_6035_ _6039_/A _6067_/A _6035_/B VDD VSS sg13cmos5l_xnor2_1
XFILLER_58_249 VDD VSS sg13cmos5l_decap_4
X_4296_ _4343_/B _4296_/A _4296_/B VDD VSS sg13cmos5l_nand2_1
XFILLER_82_720 VDD VSS sg13cmos5l_fill_2
XFILLER_82_797 VDD VSS sg13cmos5l_decap_4
XFILLER_82_786 VDD VSS sg13cmos5l_decap_8
XFILLER_54_466 VDD VSS sg13cmos5l_decap_4
XFILLER_81_296 VDD VSS sg13cmos5l_decap_8
X_6937_ _6937_/Y _6937_/A _7134_/A VDD VSS sg13cmos5l_nor2_1
X_6868_ _6877_/A _7029_/A _6913_/B VDD VSS sg13cmos5l_nand2_1
X_5819_ _5820_/B _5855_/B _5855_/A VDD VSS sg13cmos5l_xnor2_1
X_6799_ _6800_/B _6799_/A _6799_/B VDD VSS sg13cmos5l_xor2_1
XFILLER_77_514 VDD VSS sg13cmos5l_decap_4
XFILLER_77_558 VDD VSS sg13cmos5l_decap_8
XFILLER_65_709 VDD VSS sg13cmos5l_decap_8
XFILLER_66_76 VDD VSS sg13cmos5l_fill_1
XFILLER_41_683 VDD VSS sg13cmos5l_fill_1
Xoutput108 act_out[0] _6214_/Y VDD VSS sg13cmos5l_buf_1
Xoutput119 bank_A_rdata[12] _4324_/A VDD VSS sg13cmos5l_buf_1
XFILLER_56_6 VDD VSS sg13cmos5l_fill_1
X_4150_ _4316_/A quant_cfg[9] VDD VSS sg13cmos5l_buf_1
XFILLER_68_525 VDD VSS sg13cmos5l_fill_1
Xbank_A_sram.gen_ihp_256x32.u_sram_256x32_560 bank_A_sram.gen_ihp_256x32.u_sram_256x32_560/L_HI
+ VDD VSS sg13cmos5l_tiehi
Xbank_A_sram.gen_ihp_256x32.u_sram_256x32_571 bank_A_sram.gen_ihp_256x32.u_sram_256x32_571/L_HI
+ VDD VSS sg13cmos5l_tiehi
X_4081_ _4082_/B _4155_/A _3998_/A _3963_/A _4122_/A VDD VSS sg13cmos5l_a22oi_1
XFILLER_55_219 VDD VSS sg13cmos5l_fill_2
XFILLER_36_433 VDD VSS sg13cmos5l_decap_8
XFILLER_63_230 VDD VSS sg13cmos5l_fill_2
XFILLER_64_742 VDD VSS sg13cmos5l_fill_1
XFILLER_64_797 VDD VSS sg13cmos5l_fill_2
X_4983_ _5045_/B _4927_/B _4927_/A _4982_/Y VDD VSS sg13cmos5l_a21oi_1
XFILLER_63_285 VDD VSS sg13cmos5l_fill_2
X_3934_ _3935_/A _3934_/A _4203_/B VDD VSS sg13cmos5l_nand2_1
X_6722_ _6722_/Y _6722_/A1 _6742_/B _6677_/B VDD VSS sg13cmos5l_a21oi_1
Xbank_B_sram.gen_ihp_256x32.u_sram_256x32 input57/X input56/X bank_B_sram.gen_ihp_256x32.u_sram_256x32_528/L_LO
+ bank_B_sram.gen_ihp_256x32.u_sram_256x32_527/L_LO bank_B_sram.gen_ihp_256x32.u_sram_256x32_598/L_HI
+ bank_B_sram.gen_ihp_256x32.u_sram_256x32_597/L_HI bank_B_sram.gen_ihp_256x32.u_sram_256x32_495/L_LO
+ bank_B_sram.gen_ihp_256x32.u_sram_256x32_494/L_LO output155/A output154/A VSS VDD
+ VDD input58/X input55/X bank_B_sram.gen_ihp_256x32.u_sram_256x32_529/L_LO bank_B_sram.gen_ihp_256x32.u_sram_256x32_526/L_LO
+ bank_B_sram.gen_ihp_256x32.u_sram_256x32_599/L_HI bank_B_sram.gen_ihp_256x32.u_sram_256x32_596/L_HI
+ bank_B_sram.gen_ihp_256x32.u_sram_256x32_496/L_LO bank_B_sram.gen_ihp_256x32.u_sram_256x32_493/L_LO
+ output156/A output153/A input59/X input54/X bank_B_sram.gen_ihp_256x32.u_sram_256x32_530/L_LO
+ bank_B_sram.gen_ihp_256x32.u_sram_256x32_525/L_LO bank_B_sram.gen_ihp_256x32.u_sram_256x32_600/L_HI
+ bank_B_sram.gen_ihp_256x32.u_sram_256x32_595/L_HI bank_B_sram.gen_ihp_256x32.u_sram_256x32_497/L_LO
+ bank_B_sram.gen_ihp_256x32.u_sram_256x32_492/L_LO output157/A output152/A input60/X
+ input53/X bank_B_sram.gen_ihp_256x32.u_sram_256x32_531/L_LO bank_B_sram.gen_ihp_256x32.u_sram_256x32_524/L_LO
+ bank_B_sram.gen_ihp_256x32.u_sram_256x32_601/L_HI bank_B_sram.gen_ihp_256x32.u_sram_256x32_594/L_HI
+ bank_B_sram.gen_ihp_256x32.u_sram_256x32_498/L_LO bank_B_sram.gen_ihp_256x32.u_sram_256x32_491/L_LO
+ output158/A output151/A input62/X input52/X bank_B_sram.gen_ihp_256x32.u_sram_256x32_532/L_LO
+ bank_B_sram.gen_ihp_256x32.u_sram_256x32_523/L_LO bank_B_sram.gen_ihp_256x32.u_sram_256x32_602/L_HI
+ bank_B_sram.gen_ihp_256x32.u_sram_256x32_593/L_HI bank_B_sram.gen_ihp_256x32.u_sram_256x32_499/L_LO
+ bank_B_sram.gen_ihp_256x32.u_sram_256x32_490/L_LO output160/A output150/A input63/X
+ input51/X bank_B_sram.gen_ihp_256x32.u_sram_256x32_533/L_LO bank_B_sram.gen_ihp_256x32.u_sram_256x32_522/L_LO
+ bank_B_sram.gen_ihp_256x32.u_sram_256x32_603/L_HI bank_B_sram.gen_ihp_256x32.u_sram_256x32_592/L_HI
+ bank_B_sram.gen_ihp_256x32.u_sram_256x32_500/L_LO bank_B_sram.gen_ihp_256x32.u_sram_256x32_489/L_LO
+ output161/A output149/A input64/X input81/X bank_B_sram.gen_ihp_256x32.u_sram_256x32_534/L_LO
+ bank_B_sram.gen_ihp_256x32.u_sram_256x32_521/L_LO bank_B_sram.gen_ihp_256x32.u_sram_256x32_604/L_HI
+ bank_B_sram.gen_ihp_256x32.u_sram_256x32/A_BM[9] bank_B_sram.gen_ihp_256x32.u_sram_256x32_501/L_LO
+ bank_B_sram.gen_ihp_256x32.u_sram_256x32_488/L_LO output162/A output179/A input65/X
+ input80/X bank_B_sram.gen_ihp_256x32.u_sram_256x32_535/L_LO bank_B_sram.gen_ihp_256x32.u_sram_256x32_520/L_LO
+ bank_B_sram.gen_ihp_256x32.u_sram_256x32_605/L_HI bank_B_sram.gen_ihp_256x32.u_sram_256x32/A_BM[8]
+ bank_B_sram.gen_ihp_256x32.u_sram_256x32_502/L_LO bank_B_sram.gen_ihp_256x32.u_sram_256x32_487/L_LO
+ output163/A output178/A input66/X input79/X bank_B_sram.gen_ihp_256x32.u_sram_256x32_536/L_LO
+ bank_B_sram.gen_ihp_256x32.u_sram_256x32_519/L_LO bank_B_sram.gen_ihp_256x32.u_sram_256x32_606/L_HI
+ bank_B_sram.gen_ihp_256x32.u_sram_256x32/A_BM[7] bank_B_sram.gen_ihp_256x32.u_sram_256x32_503/L_LO
+ bank_B_sram.gen_ihp_256x32.u_sram_256x32_486/L_LO output164/A _6227_/B input67/X
+ input78/X bank_B_sram.gen_ihp_256x32.u_sram_256x32_537/L_LO bank_B_sram.gen_ihp_256x32.u_sram_256x32_518/L_LO
+ bank_B_sram.gen_ihp_256x32.u_sram_256x32_607/L_HI bank_B_sram.gen_ihp_256x32.u_sram_256x32/A_BM[6]
+ bank_B_sram.gen_ihp_256x32.u_sram_256x32_504/L_LO bank_B_sram.gen_ihp_256x32.u_sram_256x32_485/L_LO
+ output165/A _6225_/B input68/X input77/X bank_B_sram.gen_ihp_256x32.u_sram_256x32_538/L_LO
+ bank_B_sram.gen_ihp_256x32.u_sram_256x32_517/L_LO bank_B_sram.gen_ihp_256x32.u_sram_256x32_608/L_HI
+ bank_B_sram.gen_ihp_256x32.u_sram_256x32/A_BM[5] bank_B_sram.gen_ihp_256x32.u_sram_256x32_505/L_LO
+ bank_B_sram.gen_ihp_256x32.u_sram_256x32_484/L_LO output166/A _6223_/B input69/X
+ input76/X bank_B_sram.gen_ihp_256x32.u_sram_256x32_539/L_LO bank_B_sram.gen_ihp_256x32.u_sram_256x32_516/L_LO
+ bank_B_sram.gen_ihp_256x32.u_sram_256x32_609/L_HI bank_B_sram.gen_ihp_256x32.u_sram_256x32/A_BM[4]
+ bank_B_sram.gen_ihp_256x32.u_sram_256x32_506/L_LO bank_B_sram.gen_ihp_256x32.u_sram_256x32_483/L_LO
+ output167/A _6221_/B input70/X input75/X bank_B_sram.gen_ihp_256x32.u_sram_256x32_540/L_LO
+ bank_B_sram.gen_ihp_256x32.u_sram_256x32_515/L_LO bank_B_sram.gen_ihp_256x32.u_sram_256x32_610/L_HI
+ bank_B_sram.gen_ihp_256x32.u_sram_256x32/A_BM[3] bank_B_sram.gen_ihp_256x32.u_sram_256x32_507/L_LO
+ bank_B_sram.gen_ihp_256x32.u_sram_256x32_482/L_LO output168/A _6219_/B input71/X
+ input72/X bank_B_sram.gen_ihp_256x32.u_sram_256x32_541/L_LO bank_B_sram.gen_ihp_256x32.u_sram_256x32_514/L_LO
+ bank_B_sram.gen_ihp_256x32.u_sram_256x32_611/L_HI bank_B_sram.gen_ihp_256x32.u_sram_256x32/A_BM[2]
+ bank_B_sram.gen_ihp_256x32.u_sram_256x32_508/L_LO bank_B_sram.gen_ihp_256x32.u_sram_256x32_481/L_LO
+ output169/A _6217_/B input73/X input61/X bank_B_sram.gen_ihp_256x32.u_sram_256x32_542/L_LO
+ bank_B_sram.gen_ihp_256x32.u_sram_256x32_513/L_LO bank_B_sram.gen_ihp_256x32.u_sram_256x32_612/L_HI
+ bank_B_sram.gen_ihp_256x32.u_sram_256x32/A_BM[1] bank_B_sram.gen_ihp_256x32.u_sram_256x32_509/L_LO
+ bank_B_sram.gen_ihp_256x32.u_sram_256x32_480/L_LO output171/A _6215_/B input74/X
+ input50/X bank_B_sram.gen_ihp_256x32.u_sram_256x32_543/L_LO bank_B_sram.gen_ihp_256x32.u_sram_256x32_512/L_LO
+ bank_B_sram.gen_ihp_256x32.u_sram_256x32_613/L_HI bank_B_sram.gen_ihp_256x32.u_sram_256x32/A_BM[0]
+ bank_B_sram.gen_ihp_256x32.u_sram_256x32_510/L_LO bank_B_sram.gen_ihp_256x32.u_sram_256x32_479/L_LO
+ wire372/A _6213_/B _6188_/Y bank_B_sram.gen_ihp_256x32.u_sram_256x32_471/L_LO _6191_/Y
+ bank_B_sram.gen_ihp_256x32.u_sram_256x32_472/L_LO _6194_/Y bank_B_sram.gen_ihp_256x32.u_sram_256x32_473/L_LO
+ _6197_/Y bank_B_sram.gen_ihp_256x32.u_sram_256x32_474/L_LO _6200_/Y bank_B_sram.gen_ihp_256x32.u_sram_256x32_475/L_LO
+ _6203_/Y bank_B_sram.gen_ihp_256x32.u_sram_256x32_476/L_LO _6206_/Y bank_B_sram.gen_ihp_256x32.u_sram_256x32_477/L_LO
+ _6209_/Y bank_B_sram.gen_ihp_256x32.u_sram_256x32_478/L_LO clkbuf_1_0__f_clk_i/X
+ _6211_/Y _6211_/A bank_B_sram.gen_ihp_256x32.u_sram_256x32/A_MEN bank_B_sram.gen_ihp_256x32.u_sram_256x32/A_DLY
+ bank_B_sram.gen_ihp_256x32.u_sram_256x32_544/L_LO bank_B_sram.gen_ihp_256x32.u_sram_256x32_511/L_LO
+ bank_B_sram.gen_ihp_256x32.u_sram_256x32_546/L_LO bank_B_sram.gen_ihp_256x32.u_sram_256x32_547/L_LO
+ bank_B_sram.gen_ihp_256x32.u_sram_256x32_545/L_LO RM_IHPSG13_1P_256x32_c2_bm_bist
X_6653_ _6661_/A _6734_/A _6733_/A _6734_/B VDD VSS sg13cmos5l_nand3_1
X_5604_ _5667_/B _5606_/B _5606_/A VDD VSS sg13cmos5l_nor2_1
X_6584_ _6585_/B _6582_/B _7692_/Q VDD VSS sg13cmos5l_nand2b_1
X_5535_ _5541_/B _5535_/A VDD VSS sg13cmos5l_inv_1
X_5466_ _5467_/B _5466_/A _5466_/B VDD VSS sg13cmos5l_xor2_1
X_7205_ _7205_/Y _7205_/A _7205_/B VDD VSS sg13cmos5l_nor2_1
X_4417_ _4418_/B _4417_/A _4417_/B VDD VSS sg13cmos5l_nand2_1
Xfanout302 _4327_/B _3957_/X VDD VSS sg13cmos5l_buf_1
X_5397_ _5397_/Y _5397_/A _5397_/B VDD VSS sg13cmos5l_nor2_1
Xfanout313 _6982_/A _7189_/A VDD VSS sg13cmos5l_buf_1
Xfanout324 _5859_/B1 _5269_/X VDD VSS sg13cmos5l_buf_1
Xfanout357 _4203_/B _4303_/B VDD VSS sg13cmos5l_buf_4
X_7136_ _7136_/X _7136_/A _7181_/A VDD VSS sg13cmos5l_and2_1
Xfanout346 _4859_/B1 _4310_/X VDD VSS sg13cmos5l_buf_1
Xfanout335 _5446_/A _5135_/A VDD VSS sg13cmos5l_buf_1
X_4348_ _4349_/B _4354_/B _4411_/A VDD VSS sg13cmos5l_nor2_1
X_4279_ _4280_/B _4511_/A _4529_/A _4433_/A _4530_/A VDD VSS sg13cmos5l_a22oi_1
Xfanout379 _4207_/A _4312_/A VDD VSS sg13cmos5l_buf_1
X_7067_ _7067_/Y _7067_/A _7184_/A VDD VSS sg13cmos5l_nor2_1
XFILLER_59_558 VDD VSS sg13cmos5l_fill_1
Xfanout368 _4871_/A _4576_/A VDD VSS sg13cmos5l_buf_1
XFILLER_74_528 VDD VSS sg13cmos5l_decap_8
X_6018_ _6046_/A _6018_/A _6018_/B _6018_/C VDD VSS sg13cmos5l_nand3_1
XFILLER_46_219 VDD VSS sg13cmos5l_fill_2
XFILLER_36_46 VDD VSS sg13cmos5l_decap_8
XFILLER_43_915 VDD VSS sg13cmos5l_decap_8
XFILLER_55_786 VDD VSS sg13cmos5l_decap_4
XFILLER_42_414 VDD VSS sg13cmos5l_fill_1
XFILLER_70_756 VDD VSS sg13cmos5l_fill_2
XFILLER_78_845 VDD VSS sg13cmos5l_fill_1
XFILLER_77_31 VDD VSS sg13cmos5l_fill_1
XFILLER_78_878 VDD VSS sg13cmos5l_decap_8
XFILLER_77_333 VDD VSS sg13cmos5l_fill_2
XFILLER_45_252 VDD VSS sg13cmos5l_decap_4
XFILLER_61_723 VDD VSS sg13cmos5l_fill_2
XFILLER_60_233 VDD VSS sg13cmos5l_decap_8
XFILLER_61_756 VDD VSS sg13cmos5l_decap_4
XFILLER_60_299 VDD VSS sg13cmos5l_decap_4
X_5320_ _5321_/B _5063_/X _4996_/X _5557_/B1 _4997_/X VDD VSS sg13cmos5l_a22oi_1
X_5251_ _5252_/B _5305_/A _5305_/B VDD VSS sg13cmos5l_xor2_1
X_4202_ _4429_/A _4202_/A VDD VSS sg13cmos5l_buf_1
X_5182_ _5182_/X _5182_/A _5182_/B VDD VSS sg13cmos5l_and2_1
X_4133_ _4134_/B _4165_/A _4165_/B VDD VSS sg13cmos5l_xor2_1
XFILLER_68_355 VDD VSS sg13cmos5l_decap_8
X_4064_ _4064_/Y _4064_/A _4095_/A VDD VSS sg13cmos5l_xnor2_1
XFILLER_68_399 VDD VSS sg13cmos5l_fill_2
XFILLER_68_377 VDD VSS sg13cmos5l_decap_4
XFILLER_37_720 VDD VSS sg13cmos5l_fill_2
XFILLER_36_263 VDD VSS sg13cmos5l_decap_8
XFILLER_51_222 VDD VSS sg13cmos5l_fill_2
X_4966_ _5035_/B _4978_/B _4978_/A VDD VSS sg13cmos5l_xor2_1
X_6705_ _6705_/Y _6703_/Y _6802_/B _6704_/Y VDD VSS sg13cmos5l_a21oi_1
X_7685_ _7685_/Q _7704_/CLK _7685_/D fanout383/X VDD VSS sg13cmos5l_dfrbpq_1
X_4897_ _4959_/B _4897_/A _4897_/B VDD VSS sg13cmos5l_xor2_1
X_6636_ _6637_/B _6634_/B _7698_/Q VDD VSS sg13cmos5l_nand2b_1
X_6567_ _6568_/A _6567_/A _6567_/B _6567_/C VDD VSS sg13cmos5l_and3_1
X_5518_ _5518_/Y _5517_/A _5460_/C _5519_/A VDD VSS sg13cmos5l_o21ai_1
X_6498_ _6978_/B _6533_/C VDD VSS sg13cmos5l_inv_1
XFILLER_78_108 VDD VSS sg13cmos5l_fill_2
X_5449_ _5450_/B _5269_/X _5447_/X _5257_/X _5448_/X VDD VSS sg13cmos5l_a22oi_1
XFILLER_59_333 VDD VSS sg13cmos5l_fill_1
X_7119_ _7119_/Y _7110_/Y _6557_/A _7118_/Y VDD VSS sg13cmos5l_a21oi_1
XFILLER_47_34 VDD VSS sg13cmos5l_fill_1
Xfanout187 _6671_/A _6688_/A VDD VSS sg13cmos5l_buf_1
XFILLER_59_377 VDD VSS sg13cmos5l_fill_1
Xfanout198 _5869_/B2 _5259_/X VDD VSS sg13cmos5l_buf_1
XFILLER_74_347 VDD VSS sg13cmos5l_decap_4
XFILLER_43_701 VDD VSS sg13cmos5l_decap_8
XFILLER_82_391 VDD VSS sg13cmos5l_decap_8
XFILLER_42_255 VDD VSS sg13cmos5l_fill_1
XFILLER_42_233 VDD VSS sg13cmos5l_decap_8
XFILLER_43_767 VDD VSS sg13cmos5l_decap_4
XFILLER_63_77 VDD VSS sg13cmos5l_decap_8
XFILLER_8_28 VDD VSS sg13cmos5l_fill_1
XFILLER_78_653 VDD VSS sg13cmos5l_fill_2
XFILLER_78_686 VDD VSS sg13cmos5l_fill_2
XFILLER_66_837 VDD VSS sg13cmos5l_fill_1
XFILLER_38_517 VDD VSS sg13cmos5l_fill_2
XFILLER_81_807 VDD VSS sg13cmos5l_fill_2
XFILLER_80_339 VDD VSS sg13cmos5l_decap_8
XFILLER_74_881 VDD VSS sg13cmos5l_fill_2
X_4820_ _4821_/B _4932_/A _4640_/X _4872_/A _4641_/X VDD VSS sg13cmos5l_a22oi_1
X_4751_ _4751_/X _4751_/A VDD VSS sg13cmos5l_buf_1
X_4682_ _4683_/B _4682_/A _4734_/A VDD VSS sg13cmos5l_xnor2_1
X_7470_ _7471_/A _7472_/A1 _7268_/Y _7472_/B1 VDD VSS sg13cmos5l_o21ai_1
X_6421_ _6421_/Y _6421_/A _6420_/A VDD VSS sg13cmos5l_nor2b_1
XFILLER_108_18 VDD VSS sg13cmos5l_decap_8
X_6352_ _6363_/A _6352_/A _6352_/B VDD VSS sg13cmos5l_nand2_2
XFILLER_52_0 VDD VSS sg13cmos5l_fill_1
X_6283_ _6284_/A _6293_/A _6293_/B VDD VSS sg13cmos5l_xnor2_1
X_5303_ _5355_/A _5303_/A _5303_/B VDD VSS sg13cmos5l_and2_1
X_5234_ _5234_/X _5234_/A _5234_/B VDD VSS sg13cmos5l_and2_1
XFILLER_68_130 VDD VSS sg13cmos5l_decap_4
X_5165_ _5229_/A _5172_/A _5165_/B VDD VSS sg13cmos5l_xnor2_1
XFILLER_57_804 VDD VSS sg13cmos5l_fill_2
X_4116_ _4153_/B _4422_/A _5978_/B _4158_/B VDD VSS sg13cmos5l_nor3_1
XFILLER_57_837 VDD VSS sg13cmos5l_fill_2
X_5096_ _5096_/X _5096_/A _5096_/B VDD VSS sg13cmos5l_and2_1
X_4047_ _4047_/X _4047_/A VDD VSS sg13cmos5l_buf_1
Xbank_B_sram.gen_ihp_256x32.u_sram_256x32_607 bank_B_sram.gen_ihp_256x32.u_sram_256x32_607/L_HI
+ VDD VSS sg13cmos5l_tiehi
XFILLER_56_369 VDD VSS sg13cmos5l_decap_4
XFILLER_71_328 VDD VSS sg13cmos5l_fill_1
XFILLER_71_317 VDD VSS sg13cmos5l_fill_2
XFILLER_80_840 VDD VSS sg13cmos5l_fill_2
XFILLER_52_531 VDD VSS sg13cmos5l_decap_4
X_5998_ _5998_/Y _5998_/A VDD VSS sg13cmos5l_inv_1
X_4949_ _5007_/A _5206_/B _5257_/A _4948_/Y VDD VSS sg13cmos5l_a21o_1
X_7668_ _7668_/Q _7719_/CLK _7668_/D fanout389/X VDD VSS sg13cmos5l_dfrbpq_1
X_6619_ _6620_/B _6617_/B _7696_/Q VDD VSS sg13cmos5l_nand2b_1
X_7599_ _7627_/A _7599_/A _7599_/B VDD VSS sg13cmos5l_xnor2_1
XFILLER_79_439 VDD VSS sg13cmos5l_decap_8
XFILLER_59_130 VDD VSS sg13cmos5l_decap_4
XFILLER_75_656 VDD VSS sg13cmos5l_decap_4
XFILLER_74_122 VDD VSS sg13cmos5l_decap_4
XFILLER_47_336 VDD VSS sg13cmos5l_fill_1
XFILLER_48_859 VDD VSS sg13cmos5l_decap_4
XFILLER_75_678 VDD VSS sg13cmos5l_decap_8
XFILLER_35_509 VDD VSS sg13cmos5l_decap_8
XFILLER_63_818 VDD VSS sg13cmos5l_decap_8
XFILLER_62_317 VDD VSS sg13cmos5l_decap_4
XFILLER_43_564 VDD VSS sg13cmos5l_decap_8
Xwire374 _3932_/A wire374/A VDD VSS sg13cmos5l_buf_4
XFILLER_66_601 VDD VSS sg13cmos5l_fill_1
XFILLER_24_4 VDD VSS sg13cmos5l_decap_8
XFILLER_78_483 VDD VSS sg13cmos5l_decap_8
XFILLER_66_645 VDD VSS sg13cmos5l_fill_1
XFILLER_39_848 VDD VSS sg13cmos5l_decap_8
XFILLER_39_837 VDD VSS sg13cmos5l_fill_1
XFILLER_65_122 VDD VSS sg13cmos5l_fill_1
XFILLER_54_829 VDD VSS sg13cmos5l_decap_8
XFILLER_54_818 VDD VSS sg13cmos5l_fill_2
X_6970_ _6970_/Y _6970_/A _6970_/B VDD VSS sg13cmos5l_nand2_1
X_5921_ _5925_/A _5961_/A _5921_/B VDD VSS sg13cmos5l_xnor2_1
XFILLER_81_659 VDD VSS sg13cmos5l_decap_8
XFILLER_80_136 VDD VSS sg13cmos5l_decap_8
X_5852_ _5852_/Y _5852_/A _5799_/A VDD VSS sg13cmos5l_nor2b_1
XFILLER_61_350 VDD VSS sg13cmos5l_decap_8
XFILLER_62_895 VDD VSS sg13cmos5l_decap_4
X_5783_ _5845_/A _6042_/A _5729_/B _5782_/Y VDD VSS sg13cmos5l_o21ai_1
X_4803_ _4803_/X _4803_/A _4803_/B VDD VSS sg13cmos5l_and2_1
X_7522_ _7523_/A _7522_/A1 _7524_/A _7342_/B VDD VSS sg13cmos5l_a21oi_1
X_4734_ _4734_/Y _4734_/A _4682_/A VDD VSS sg13cmos5l_nor2b_1
X_7453_ _7458_/A _7453_/A _7453_/B _7589_/B VDD VSS sg13cmos5l_nand3_1
X_4665_ _4671_/B _4665_/A _4665_/B VDD VSS sg13cmos5l_xnor2_1
X_7384_ _7509_/B _7387_/B _7424_/A VDD VSS sg13cmos5l_nand2_1
X_4596_ _4597_/B _4627_/A _4596_/B VDD VSS sg13cmos5l_xnor2_1
X_6404_ _6406_/A _6404_/A _6827_/A VDD VSS sg13cmos5l_nand2_2
X_6335_ _6342_/B _6335_/A _6335_/B VDD VSS sg13cmos5l_nor2_2
X_6266_ _6267_/B _6268_/B VDD VSS sg13cmos5l_inv_1
XFILLER_69_472 VDD VSS sg13cmos5l_decap_8
X_6197_ _6197_/Y _6209_/A1 _6197_/A2 _6196_/Y VDD VSS sg13cmos5l_a21oi_1
X_5217_ _5219_/A _5156_/B _5217_/B VDD VSS sg13cmos5l_nand2b_1
X_5148_ _5197_/A _5460_/B _5443_/A _5147_/Y VDD VSS sg13cmos5l_a21o_1
XFILLER_57_645 VDD VSS sg13cmos5l_fill_1
X_5079_ _5138_/A _5206_/B _5382_/A _5078_/Y VDD VSS sg13cmos5l_a21o_1
XFILLER_38_892 VDD VSS sg13cmos5l_decap_8
XFILLER_57_689 VDD VSS sg13cmos5l_decap_4
XFILLER_53_884 VDD VSS sg13cmos5l_fill_2
XFILLER_53_895 VDD VSS sg13cmos5l_fill_2
XFILLER_79_247 VDD VSS sg13cmos5l_decap_8
XFILLER_69_76 VDD VSS sg13cmos5l_decap_8
XFILLER_67_409 VDD VSS sg13cmos5l_fill_2
XFILLER_75_497 VDD VSS sg13cmos5l_decap_8
XFILLER_62_147 VDD VSS sg13cmos5l_fill_1
XFILLER_44_873 VDD VSS sg13cmos5l_fill_2
XFILLER_71_692 VDD VSS sg13cmos5l_decap_4
X_4450_ _4451_/B _4688_/A _4529_/A _4631_/A _4530_/A VDD VSS sg13cmos5l_a22oi_1
X_4381_ _4457_/B _4381_/A _4381_/B VDD VSS sg13cmos5l_xor2_1
Xrebuffer1206 _4144_/B _4143_/Y VDD VSS sg13cmos5l_buf_1
Xrebuffer1217 rebuffer1217/X rebuffer1218/X VDD VSS sg13cmos5l_buf_1
X_6120_ _6145_/B _6120_/A _6123_/B VDD VSS sg13cmos5l_nand2_1
Xrebuffer1228 _4121_/A1 _4092_/B VDD VSS sg13cmos5l_buf_1
Xrebuffer1239 rebuffer1239/X rebuffer1240/X VDD VSS sg13cmos5l_buf_1
X_6051_ _6094_/B _6051_/A _6032_/A VDD VSS sg13cmos5l_nor2b_1
XFILLER_39_623 VDD VSS sg13cmos5l_decap_4
X_5002_ _5054_/A _5442_/A _5002_/B VDD VSS sg13cmos5l_xnor2_1
XFILLER_39_667 VDD VSS sg13cmos5l_decap_8
XFILLER_38_144 VDD VSS sg13cmos5l_decap_8
XFILLER_81_401 VDD VSS sg13cmos5l_decap_8
XFILLER_66_475 VDD VSS sg13cmos5l_fill_1
XFILLER_54_659 VDD VSS sg13cmos5l_fill_2
X_6953_ _6953_/X _6953_/A _7008_/B VDD VSS sg13cmos5l_and2_1
XFILLER_81_478 VDD VSS sg13cmos5l_decap_4
XFILLER_35_884 VDD VSS sg13cmos5l_fill_2
X_6884_ _6884_/Y _6883_/Y _6960_/B VDD VSS sg13cmos5l_nand2b_1
X_5904_ _5905_/B _5904_/A _5945_/A VDD VSS sg13cmos5l_nand2_1
X_5835_ _5837_/A _5835_/A _5835_/B VDD VSS sg13cmos5l_nor2_1
X_5766_ _5767_/B _5797_/A _5797_/B VDD VSS sg13cmos5l_xor2_1
X_7505_ _7620_/A _7504_/Y _7510_/A VDD VSS sg13cmos5l_nand2b_1
X_5697_ _5704_/A _5982_/A _5697_/B VDD VSS sg13cmos5l_xnor2_1
X_4717_ _4720_/A _4732_/A _4717_/B VDD VSS sg13cmos5l_xnor2_1
X_4648_ _4648_/Y _4648_/A _4648_/B VDD VSS sg13cmos5l_nor2_1
X_7436_ _7587_/A _7456_/A _7436_/B VDD VSS sg13cmos5l_xnor2_1
X_7367_ _7513_/A _7359_/A _7430_/A VDD VSS sg13cmos5l_nand2b_1
X_4579_ _4580_/B _4623_/A _4623_/B VDD VSS sg13cmos5l_xor2_1
X_6318_ _6787_/A _6318_/A _6320_/B VDD VSS sg13cmos5l_nor2b_2
X_7298_ _7298_/Y _7248_/X _7136_/A _7297_/Y VDD VSS sg13cmos5l_o21ai_1
XFILLER_39_57 VDD VSS sg13cmos5l_decap_8
X_6249_ _6533_/C _6972_/B _6915_/A VDD VSS sg13cmos5l_nand2_2
XFILLER_72_445 VDD VSS sg13cmos5l_fill_2
XFILLER_55_67 VDD VSS sg13cmos5l_fill_2
XFILLER_44_158 VDD VSS sg13cmos5l_decap_4
XFILLER_60_618 VDD VSS sg13cmos5l_fill_2
XFILLER_71_33 VDD VSS sg13cmos5l_fill_2
XFILLER_40_342 VDD VSS sg13cmos5l_decap_8
XFILLER_68_707 VDD VSS sg13cmos5l_fill_2
XFILLER_48_453 VDD VSS sg13cmos5l_decap_8
XFILLER_76_773 VDD VSS sg13cmos5l_fill_2
XFILLER_75_272 VDD VSS sg13cmos5l_fill_2
XFILLER_75_250 VDD VSS sg13cmos5l_fill_2
XFILLER_36_637 VDD VSS sg13cmos5l_decap_4
XFILLER_35_125 VDD VSS sg13cmos5l_decap_4
X_3950_ _3950_/X _3950_/A VDD VSS sg13cmos5l_buf_1
XFILLER_51_618 VDD VSS sg13cmos5l_fill_1
X_5620_ _5658_/A _5564_/B _5564_/A _5619_/Y VDD VSS sg13cmos5l_a21oi_1
X_5551_ _5553_/A _5552_/A _5552_/B _5552_/C VDD VSS sg13cmos5l_a21oi_1
X_4502_ _4502_/Y _4503_/B _4503_/A VDD VSS sg13cmos5l_nor2_1
X_7221_ _7222_/B _7246_/A _7221_/B VDD VSS sg13cmos5l_nor2_1
X_5482_ _5489_/C _5483_/B _5482_/B VDD VSS sg13cmos5l_nand2b_1
X_4433_ _4433_/X _4433_/A VDD VSS sg13cmos5l_buf_1
X_7152_ _7152_/Y _7164_/A _6994_/A _7126_/B VDD VSS sg13cmos5l_o21ai_1
X_4364_ _4364_/Y _6111_/B _4621_/A VDD VSS sg13cmos5l_nand2_1
X_4295_ _4343_/A _4295_/A _4295_/B VDD VSS sg13cmos5l_nand2_1
X_6103_ _6103_/X _6103_/A _6103_/B VDD VSS sg13cmos5l_and2_1
X_7083_ _7083_/Y _6975_/Y _7078_/B _7108_/S VDD VSS sg13cmos5l_a21oi_1
X_6034_ _6035_/B _6068_/A _6068_/B VDD VSS sg13cmos5l_xor2_1
XFILLER_67_740 VDD VSS sg13cmos5l_fill_2
XFILLER_66_261 VDD VSS sg13cmos5l_decap_8
XFILLER_82_754 VDD VSS sg13cmos5l_fill_1
XFILLER_54_423 VDD VSS sg13cmos5l_fill_2
XFILLER_42_607 VDD VSS sg13cmos5l_fill_1
XFILLER_25_15 VDD VSS sg13cmos5l_decap_8
X_6936_ _7134_/A _7072_/A _6913_/B _6935_/X VDD VSS sg13cmos5l_a21oi_1
XFILLER_54_456 VDD VSS sg13cmos5l_decap_4
XFILLER_81_275 VDD VSS sg13cmos5l_decap_8
XFILLER_41_128 VDD VSS sg13cmos5l_decap_4
XFILLER_35_692 VDD VSS sg13cmos5l_decap_8
X_6867_ _7029_/A _6867_/A VDD VSS sg13cmos5l_inv_1
X_5818_ _5855_/A _5768_/B _5768_/A _5817_/X VDD VSS sg13cmos5l_a21o_1
X_6798_ _6798_/Y _6798_/A _6798_/B VDD VSS sg13cmos5l_xnor2_1
X_5749_ _5749_/X _5749_/A _5749_/B VDD VSS sg13cmos5l_and2_1
XFILLER_41_25 VDD VSS sg13cmos5l_fill_1
X_7419_ _7431_/A _7318_/Y _7397_/A _7399_/A VDD VSS sg13cmos5l_a21o_1
XFILLER_2_19 VDD VSS sg13cmos5l_decap_8
XFILLER_58_751 VDD VSS sg13cmos5l_fill_2
XFILLER_58_762 VDD VSS sg13cmos5l_fill_1
XFILLER_72_231 VDD VSS sg13cmos5l_fill_1
XFILLER_73_798 VDD VSS sg13cmos5l_decap_8
XFILLER_72_286 VDD VSS sg13cmos5l_fill_2
XFILLER_82_87 VDD VSS sg13cmos5l_decap_4
XFILLER_60_459 VDD VSS sg13cmos5l_fill_2
XFILLER_63_8 VDD VSS sg13cmos5l_decap_4
Xoutput109 act_out[1] _6216_/Y VDD VSS sg13cmos5l_buf_1
Xrebuffer690 rebuffer690/X rebuffer691/X VDD VSS sg13cmos5l_buf_1
Xbank_A_sram.gen_ihp_256x32.u_sram_256x32_550 bank_A_sram.gen_ihp_256x32.u_sram_256x32/A_BM[2]
+ VDD VSS sg13cmos5l_tiehi
Xbank_A_sram.gen_ihp_256x32.u_sram_256x32_561 bank_A_sram.gen_ihp_256x32.u_sram_256x32_561/L_HI
+ VDD VSS sg13cmos5l_tiehi
Xbank_A_sram.gen_ihp_256x32.u_sram_256x32_572 bank_A_sram.gen_ihp_256x32.u_sram_256x32_572/L_HI
+ VDD VSS sg13cmos5l_tiehi
X_4080_ _4093_/B _4063_/B _4063_/A _4079_/Y VDD VSS sg13cmos5l_a21oi_1
XFILLER_48_261 VDD VSS sg13cmos5l_fill_2
XFILLER_49_795 VDD VSS sg13cmos5l_fill_1
XFILLER_36_412 VDD VSS sg13cmos5l_decap_8
XFILLER_64_721 VDD VSS sg13cmos5l_fill_2
XFILLER_64_776 VDD VSS sg13cmos5l_decap_8
X_4982_ _4982_/Y _4982_/A _4926_/A VDD VSS sg13cmos5l_nor2b_1
X_3933_ _4303_/B _3999_/B VDD VSS sg13cmos5l_buf_2
X_6721_ _6721_/Y _6721_/A _6721_/B VDD VSS sg13cmos5l_xnor2_1
XFILLER_51_448 VDD VSS sg13cmos5l_fill_1
X_6652_ _6733_/A _6652_/A VDD VSS sg13cmos5l_inv_1
X_5603_ _5606_/A _5603_/A VDD VSS sg13cmos5l_inv_1
X_6583_ _6585_/A _6583_/A _6771_/A VDD VSS sg13cmos5l_nand2_2
X_5534_ _5535_/A _5601_/A _5534_/B VDD VSS sg13cmos5l_xnor2_1
X_5465_ _5466_/B _5512_/A _5512_/B VDD VSS sg13cmos5l_xor2_1
X_7204_ _7324_/B _7215_/A VDD VSS sg13cmos5l_buf_4
X_4416_ _4418_/A _4416_/A _4416_/B VDD VSS sg13cmos5l_nand2_1
Xfanout303 _5460_/A _5206_/A VDD VSS sg13cmos5l_buf_1
X_5396_ _5397_/B _5460_/A _5460_/B _5396_/C VDD VSS sg13cmos5l_nor3_1
Xfanout314 _6416_/A _6259_/X VDD VSS sg13cmos5l_buf_1
X_7135_ _7136_/A _7138_/B _6944_/Y _7134_/Y VDD VSS sg13cmos5l_o21ai_1
X_4347_ _4411_/A _4347_/A _4249_/A VDD VSS sg13cmos5l_nor2b_1
XFILLER_59_537 VDD VSS sg13cmos5l_fill_1
Xfanout325 _5792_/B1 _5257_/X VDD VSS sg13cmos5l_buf_1
Xfanout336 _5430_/B1 _4872_/X VDD VSS sg13cmos5l_buf_1
Xfanout347 _4799_/B1 _4262_/X VDD VSS sg13cmos5l_buf_2
Xfanout358 _3931_/A _3930_/X VDD VSS sg13cmos5l_buf_1
X_4278_ _4319_/A _4327_/B _4574_/A _4277_/Y VDD VSS sg13cmos5l_a21o_1
Xfanout369 _4168_/A _4272_/A VDD VSS sg13cmos5l_buf_1
X_7066_ _7184_/A _6943_/B _7085_/B _7065_/X VDD VSS sg13cmos5l_a21oi_1
X_6017_ _7699_/D _6017_/A _6017_/B VDD VSS sg13cmos5l_xnor2_1
XFILLER_46_209 VDD VSS sg13cmos5l_fill_2
XFILLER_39_294 VDD VSS sg13cmos5l_fill_1
XFILLER_82_562 VDD VSS sg13cmos5l_decap_4
XFILLER_42_437 VDD VSS sg13cmos5l_fill_1
X_6919_ _7054_/A _6960_/B _6732_/Y _6918_/Y VDD VSS sg13cmos5l_o21ai_1
XFILLER_50_470 VDD VSS sg13cmos5l_decap_8
XFILLER_52_68 VDD VSS sg13cmos5l_fill_2
XFILLER_78_802 VDD VSS sg13cmos5l_fill_2
XFILLER_78_868 VDD VSS sg13cmos5l_decap_8
XFILLER_77_389 VDD VSS sg13cmos5l_decap_8
XFILLER_46_732 VDD VSS sg13cmos5l_fill_2
XFILLER_58_581 VDD VSS sg13cmos5l_fill_2
XFILLER_61_702 VDD VSS sg13cmos5l_fill_1
XFILLER_45_286 VDD VSS sg13cmos5l_fill_2
XFILLER_60_223 VDD VSS sg13cmos5l_fill_2
X_5250_ _5305_/B _5196_/B _5196_/A _5249_/X VDD VSS sg13cmos5l_a21oi_1
X_4201_ _4202_/A _6053_/B _6052_/A VDD VSS sg13cmos5l_nor2b_1
X_5181_ _5184_/A _5243_/S _5181_/B VDD VSS sg13cmos5l_xnor2_1
X_4132_ _4165_/B _4528_/A _4132_/B VDD VSS sg13cmos5l_xnor2_1
XFILLER_69_857 VDD VSS sg13cmos5l_fill_1
X_4063_ _4064_/A _4063_/A _4063_/B VDD VSS sg13cmos5l_xor2_1
XFILLER_36_242 VDD VSS sg13cmos5l_decap_8
X_4965_ _4978_/A _4979_/B _4979_/A VDD VSS sg13cmos5l_xor2_1
XFILLER_52_779 VDD VSS sg13cmos5l_decap_4
X_6704_ _6704_/Y _6704_/A VDD VSS sg13cmos5l_inv_1
X_4896_ _4897_/B _4928_/A _4896_/B VDD VSS sg13cmos5l_xnor2_1
X_7684_ _7684_/Q clkload1/A _7684_/D fanout384/X VDD VSS sg13cmos5l_dfrbpq_1
X_6635_ _6637_/A _6635_/A _6754_/A VDD VSS sg13cmos5l_nand2_2
X_6566_ _6566_/Y _6567_/C _6567_/A VDD VSS sg13cmos5l_nor2_1
X_5517_ _5519_/A _5517_/A _5643_/A VDD VSS sg13cmos5l_nand2_1
Xclkbuf_1_1__f_clk_i clkbuf_1_1__f_clk_i/X clkbuf_0_clk_i/X VDD VSS sg13cmos5l_buf_8
X_6497_ _6505_/A _6837_/A _6836_/A _6837_/B VDD VSS sg13cmos5l_nand3_1
X_5448_ _5448_/X _5448_/A VDD VSS sg13cmos5l_buf_1
X_5379_ _5405_/A _5343_/B _5343_/A _5378_/Y VDD VSS sg13cmos5l_a21oi_1
X_7118_ _7118_/Y _7290_/A _7118_/B VDD VSS sg13cmos5l_nand2b_1
X_7049_ _7126_/B _7484_/B _7080_/A VDD VSS sg13cmos5l_nand2_2
Xfanout188 _6527_/A _6459_/X VDD VSS sg13cmos5l_buf_1
Xfanout199 _5869_/A2 _5258_/X VDD VSS sg13cmos5l_buf_1
XFILLER_74_326 VDD VSS sg13cmos5l_decap_8
XFILLER_42_212 VDD VSS sg13cmos5l_decap_8
XFILLER_63_12 VDD VSS sg13cmos5l_fill_2
XFILLER_43_746 VDD VSS sg13cmos5l_decap_8
XFILLER_63_45 VDD VSS sg13cmos5l_decap_8
XFILLER_70_565 VDD VSS sg13cmos5l_decap_8
XFILLER_51_790 VDD VSS sg13cmos5l_decap_4
XFILLER_77_153 VDD VSS sg13cmos5l_decap_4
XFILLER_77_197 VDD VSS sg13cmos5l_decap_8
XFILLER_46_551 VDD VSS sg13cmos5l_decap_8
XFILLER_80_318 VDD VSS sg13cmos5l_decap_8
XFILLER_74_893 VDD VSS sg13cmos5l_fill_2
X_4750_ _4750_/X _4750_/A VDD VSS sg13cmos5l_buf_1
XFILLER_42_790 VDD VSS sg13cmos5l_fill_2
X_4681_ _4734_/A _4637_/B _4637_/A _4680_/X VDD VSS sg13cmos5l_a21oi_1
X_6420_ _6431_/A _6420_/A _6420_/B VDD VSS sg13cmos5l_nor2_2
X_6351_ _6352_/B _6349_/B _7667_/Q VDD VSS sg13cmos5l_nand2b_1
Xclkbuf_4_2_0_clk_i_regs _7728_/CLK clkbuf_0_clk_i_regs/X VDD VSS sg13cmos5l_buf_8
X_5302_ _5547_/A _5302_/A VDD VSS sg13cmos5l_buf_1
XFILLER_45_0 VDD VSS sg13cmos5l_fill_2
X_6282_ _6293_/B _6586_/B _6576_/A VDD VSS sg13cmos5l_nor2_2
X_5233_ _5236_/A _5233_/A _5233_/B VDD VSS sg13cmos5l_nand2_1
X_5164_ _5165_/B _5173_/B _5173_/A VDD VSS sg13cmos5l_xor2_1
X_4115_ _4158_/B _5977_/A VDD VSS sg13cmos5l_inv_1
XFILLER_68_175 VDD VSS sg13cmos5l_decap_4
X_5095_ _5110_/B _5095_/A _5095_/B VDD VSS sg13cmos5l_xor2_1
XFILLER_57_849 VDD VSS sg13cmos5l_decap_8
XFILLER_72_808 VDD VSS sg13cmos5l_decap_8
X_4046_ _4047_/A _4046_/A VDD VSS sg13cmos5l_buf_1
Xbank_B_sram.gen_ihp_256x32.u_sram_256x32_608 bank_B_sram.gen_ihp_256x32.u_sram_256x32_608/L_HI
+ VDD VSS sg13cmos5l_tiehi
XFILLER_65_893 VDD VSS sg13cmos5l_decap_4
X_5997_ _6004_/B _5997_/A VDD VSS sg13cmos5l_inv_1
X_4948_ _4948_/Y _4948_/A _4948_/B VDD VSS sg13cmos5l_nor2_1
X_7667_ _7667_/Q _7719_/CLK _7667_/D fanout389/X VDD VSS sg13cmos5l_dfrbpq_1
X_4879_ _4924_/B _5446_/A _4879_/B VDD VSS sg13cmos5l_xnor2_1
X_6618_ _6620_/A _6618_/A _6756_/A VDD VSS sg13cmos5l_nand2_2
X_7598_ _7599_/A _7598_/A _7598_/B VDD VSS sg13cmos5l_nand2_2
X_6549_ _6560_/B _6549_/A _6549_/B VDD VSS sg13cmos5l_nand2_2
XFILLER_58_67 VDD VSS sg13cmos5l_fill_1
XFILLER_75_635 VDD VSS sg13cmos5l_decap_8
XFILLER_74_101 VDD VSS sg13cmos5l_fill_1
XFILLER_74_156 VDD VSS sg13cmos5l_fill_1
XFILLER_74_178 VDD VSS sg13cmos5l_decap_4
XFILLER_43_510 VDD VSS sg13cmos5l_decap_8
XFILLER_74_88 VDD VSS sg13cmos5l_fill_1
XFILLER_43_521 VDD VSS sg13cmos5l_fill_2
XFILLER_31_6 VDD VSS sg13cmos5l_fill_1
XFILLER_78_462 VDD VSS sg13cmos5l_decap_8
XFILLER_78_495 VDD VSS sg13cmos5l_decap_8
XFILLER_38_326 VDD VSS sg13cmos5l_decap_8
XFILLER_65_145 VDD VSS sg13cmos5l_decap_8
XFILLER_81_638 VDD VSS sg13cmos5l_decap_8
XFILLER_80_115 VDD VSS sg13cmos5l_decap_8
X_5920_ _5921_/B _5962_/A _5962_/B VDD VSS sg13cmos5l_xor2_1
X_5851_ _5882_/A _5851_/A _5851_/B VDD VSS sg13cmos5l_nand2_1
X_5782_ _5782_/Y _5782_/A _5782_/B VDD VSS sg13cmos5l_nand2_1
X_4802_ _4805_/A _4858_/S _4802_/B VDD VSS sg13cmos5l_xnor2_1
XFILLER_61_395 VDD VSS sg13cmos5l_fill_1
XFILLER_61_384 VDD VSS sg13cmos5l_fill_1
X_7521_ _7562_/D _7619_/C VDD VSS sg13cmos5l_inv_1
X_4733_ _4792_/A _4716_/B _4716_/A _4732_/Y VDD VSS sg13cmos5l_a21o_1
X_7452_ _7589_/B _7452_/A _7464_/B VDD VSS sg13cmos5l_nand2_1
X_4664_ _4665_/B _4721_/B _4721_/A VDD VSS sg13cmos5l_xor2_1
X_6403_ _6827_/A _7672_/Q _6403_/B VDD VSS sg13cmos5l_xnor2_1
X_4595_ _4596_/B _4595_/A _4595_/B VDD VSS sg13cmos5l_xor2_1
X_7383_ _7387_/B _7349_/X _7247_/Y _7382_/Y VDD VSS sg13cmos5l_o21ai_1
X_6334_ _6336_/A _7091_/A _6630_/B VDD VSS sg13cmos5l_nor2_1
X_6265_ _6268_/B _6275_/A _6275_/B _6577_/B VDD VSS sg13cmos5l_nand3_1
X_5216_ _5238_/B _5286_/B _5216_/B VDD VSS sg13cmos5l_xnor2_1
X_6196_ _6196_/Y _6223_/A _6196_/B VDD VSS sg13cmos5l_nor2_1
X_5147_ _5147_/Y _5147_/A _5147_/B VDD VSS sg13cmos5l_nor2_1
X_5078_ _5078_/Y _5078_/A _5078_/B VDD VSS sg13cmos5l_nor2_1
X_4029_ _4030_/B _4155_/A _3950_/A _3963_/A _3981_/A VDD VSS sg13cmos5l_a22oi_1
XFILLER_38_871 VDD VSS sg13cmos5l_decap_8
XFILLER_56_178 VDD VSS sg13cmos5l_fill_1
XFILLER_56_189 VDD VSS sg13cmos5l_decap_4
XFILLER_72_649 VDD VSS sg13cmos5l_fill_1
XFILLER_65_690 VDD VSS sg13cmos5l_fill_1
XFILLER_52_340 VDD VSS sg13cmos5l_fill_2
XFILLER_44_69 VDD VSS sg13cmos5l_fill_2
XFILLER_52_373 VDD VSS sg13cmos5l_fill_1
XFILLER_52_384 VDD VSS sg13cmos5l_fill_2
X_7719_ _7719_/Q _7719_/CLK _7719_/D fanout389/X VDD VSS sg13cmos5l_dfrbpq_1
XFILLER_69_33 VDD VSS sg13cmos5l_fill_2
XFILLER_79_226 VDD VSS sg13cmos5l_decap_8
XFILLER_69_99 VDD VSS sg13cmos5l_fill_2
XFILLER_75_421 VDD VSS sg13cmos5l_fill_1
XFILLER_75_476 VDD VSS sg13cmos5l_decap_8
XFILLER_47_156 VDD VSS sg13cmos5l_fill_1
XFILLER_44_852 VDD VSS sg13cmos5l_decap_8
XFILLER_93_8 VDD VSS sg13cmos5l_decap_8
XFILLER_43_395 VDD VSS sg13cmos5l_decap_8
X_4380_ _4381_/B _4426_/A _4426_/B VDD VSS sg13cmos5l_xor2_1
Xrebuffer1207 _5934_/A _5936_/A VDD VSS sg13cmos5l_buf_1
Xrebuffer1229 _5236_/B _5298_/A VDD VSS sg13cmos5l_buf_1
Xrebuffer1218 rebuffer1218/X rebuffer1219/X VDD VSS sg13cmos5l_buf_1
X_6050_ _6093_/B _6031_/B _6031_/A _6049_/X VDD VSS sg13cmos5l_a21o_1
X_5001_ _5002_/B _5557_/B1 _5258_/A _5493_/B1 _5259_/A VDD VSS sg13cmos5l_a22oi_1
XFILLER_39_646 VDD VSS sg13cmos5l_decap_8
XFILLER_38_123 VDD VSS sg13cmos5l_decap_8
XFILLER_54_616 VDD VSS sg13cmos5l_decap_4
XFILLER_81_457 VDD VSS sg13cmos5l_decap_8
XFILLER_53_148 VDD VSS sg13cmos5l_decap_8
XFILLER_53_137 VDD VSS sg13cmos5l_fill_1
X_6952_ _6953_/A _6944_/Y _6937_/A _6951_/Y VDD VSS sg13cmos5l_a21oi_1
X_6883_ _6883_/Y _6883_/A _6883_/B VDD VSS sg13cmos5l_xnor2_1
X_5903_ _5903_/Y _5945_/A _5904_/A VDD VSS sg13cmos5l_nor2_1
X_5834_ _5835_/A _5834_/A VDD VSS sg13cmos5l_inv_1
X_5765_ _5797_/B _5872_/A _5765_/B VDD VSS sg13cmos5l_xnor2_1
X_7504_ _7504_/Y _7504_/A1 _7506_/A _7381_/B VDD VSS sg13cmos5l_a21oi_1
X_5696_ _5697_/B _5949_/B1 _5941_/A2 _5909_/B1 _5941_/B2 VDD VSS sg13cmos5l_a22oi_1
X_4716_ _4717_/B _4716_/A _4716_/B VDD VSS sg13cmos5l_xor2_1
X_4647_ _4648_/B _5014_/A _4647_/B _4647_/C VDD VSS sg13cmos5l_nor3_1
X_7435_ _7436_/B _7472_/A1 _7130_/Y _7472_/B1 VDD VSS sg13cmos5l_o21ai_1
X_7366_ _7557_/A _7366_/A VDD VSS sg13cmos5l_buf_4
X_6317_ _6320_/B _6317_/A _7664_/Q _6317_/C VDD VSS sg13cmos5l_nand3_1
X_4578_ _4623_/B _4578_/A _4578_/B VDD VSS sg13cmos5l_xnor2_1
X_7297_ _7297_/Y _7297_/A _7297_/B VDD VSS sg13cmos5l_nor2_1
XFILLER_39_36 VDD VSS sg13cmos5l_decap_8
X_6248_ _6972_/B _6768_/A VDD VSS sg13cmos5l_inv_16
X_6179_ _6180_/A _6172_/B _6172_/A _6178_/Y VDD VSS sg13cmos5l_a21oi_1
XFILLER_58_933 VDD VSS sg13cmos5l_fill_1
XFILLER_58_922 VDD VSS sg13cmos5l_decap_8
XFILLER_57_454 VDD VSS sg13cmos5l_fill_2
XFILLER_73_925 VDD VSS sg13cmos5l_decap_8
XFILLER_72_402 VDD VSS sg13cmos5l_decap_4
XFILLER_44_126 VDD VSS sg13cmos5l_decap_8
XFILLER_44_137 VDD VSS sg13cmos5l_fill_1
XFILLER_57_498 VDD VSS sg13cmos5l_fill_1
XFILLER_41_800 VDD VSS sg13cmos5l_decap_8
XFILLER_53_682 VDD VSS sg13cmos5l_fill_2
XFILLER_80_490 VDD VSS sg13cmos5l_decap_8
XFILLER_41_866 VDD VSS sg13cmos5l_fill_2
XFILLER_41_855 VDD VSS sg13cmos5l_fill_1
XFILLER_67_218 VDD VSS sg13cmos5l_decap_8
XFILLER_49_933 VDD VSS sg13cmos5l_fill_1
XFILLER_49_922 VDD VSS sg13cmos5l_fill_1
XFILLER_64_903 VDD VSS sg13cmos5l_fill_1
XFILLER_35_148 VDD VSS sg13cmos5l_decap_4
XFILLER_44_671 VDD VSS sg13cmos5l_fill_1
XFILLER_44_682 VDD VSS sg13cmos5l_fill_1
XFILLER_50_118 VDD VSS sg13cmos5l_decap_8
X_5550_ _5552_/C _5615_/B _5550_/B VDD VSS sg13cmos5l_xnor2_1
X_5481_ _5482_/B _5481_/A _5416_/A VDD VSS sg13cmos5l_nor2b_1
X_4501_ _4503_/A _4439_/B _4439_/A _4500_/X VDD VSS sg13cmos5l_a21oi_1
X_7220_ _7369_/B _7246_/A _6938_/Y _7219_/Y VDD VSS sg13cmos5l_o21ai_1
X_4432_ _4439_/A _4432_/A _4432_/B VDD VSS sg13cmos5l_xnor2_1
X_7151_ _7177_/A _7151_/A _7650_/A _7651_/B VDD VSS sg13cmos5l_nand3_1
X_4363_ _4416_/B _4492_/A _4363_/B VDD VSS sg13cmos5l_nor2_1
X_4294_ _7670_/D _4351_/B _4294_/B VDD VSS sg13cmos5l_xnor2_1
X_6102_ _6105_/A _6132_/B _6132_/A VDD VSS sg13cmos5l_xor2_1
X_7082_ _7082_/Y _7082_/A _7085_/B VDD VSS sg13cmos5l_nand2_1
X_6033_ _6068_/B _5994_/B _6033_/B VDD VSS sg13cmos5l_nand2b_1
XFILLER_58_229 VDD VSS sg13cmos5l_decap_8
XFILLER_58_218 VDD VSS sg13cmos5l_decap_4
XFILLER_67_774 VDD VSS sg13cmos5l_decap_4
XFILLER_54_402 VDD VSS sg13cmos5l_fill_2
XFILLER_82_777 VDD VSS sg13cmos5l_fill_1
XFILLER_81_254 VDD VSS sg13cmos5l_decap_8
XFILLER_70_928 VDD VSS sg13cmos5l_decap_4
XFILLER_70_906 VDD VSS sg13cmos5l_fill_1
XFILLER_35_660 VDD VSS sg13cmos5l_fill_1
X_6935_ _6935_/X _7061_/A _6972_/B VDD VSS sg13cmos5l_and2_1
X_6866_ _6867_/A _6862_/X _6939_/A _6865_/Y VDD VSS sg13cmos5l_a21oi_1
X_5817_ _5817_/X _5817_/A _5817_/B VDD VSS sg13cmos5l_and2_1
XFILLER_50_674 VDD VSS sg13cmos5l_decap_8
X_6797_ _6797_/Y _6797_/A _7030_/B VDD VSS sg13cmos5l_nand2_1
X_5748_ _5751_/A _5791_/S _5748_/B VDD VSS sg13cmos5l_xnor2_1
XFILLER_41_59 VDD VSS sg13cmos5l_decap_8
X_5679_ _5727_/A _5679_/A _5679_/B VDD VSS sg13cmos5l_nand2_1
X_7418_ _7575_/A _7418_/A _7579_/A VDD VSS sg13cmos5l_nand2_2
X_7349_ _7349_/X _7349_/A VDD VSS sg13cmos5l_buf_1
XFILLER_77_538 VDD VSS sg13cmos5l_fill_2
XFILLER_73_700 VDD VSS sg13cmos5l_fill_1
XFILLER_46_925 VDD VSS sg13cmos5l_decap_8
XFILLER_73_722 VDD VSS sg13cmos5l_fill_1
XFILLER_45_424 VDD VSS sg13cmos5l_decap_4
XFILLER_73_766 VDD VSS sg13cmos5l_fill_1
XFILLER_73_755 VDD VSS sg13cmos5l_decap_8
XFILLER_61_928 VDD VSS sg13cmos5l_decap_4
XFILLER_82_66 VDD VSS sg13cmos5l_decap_4
XFILLER_60_449 VDD VSS sg13cmos5l_fill_2
Xrebuffer691 rebuffer691/X rebuffer692/X VDD VSS sg13cmos5l_buf_1
Xclkbuf_4_7_0_clk_i_regs clkload4/A clkbuf_0_clk_i_regs/X VDD VSS sg13cmos5l_buf_8
Xrebuffer680 _6863_/A1 _6555_/A VDD VSS sg13cmos5l_buf_1
XFILLER_68_516 VDD VSS sg13cmos5l_decap_8
Xbank_A_sram.gen_ihp_256x32.u_sram_256x32_551 bank_A_sram.gen_ihp_256x32.u_sram_256x32/A_BM[3]
+ VDD VSS sg13cmos5l_tiehi
Xbank_A_sram.gen_ihp_256x32.u_sram_256x32_562 bank_A_sram.gen_ihp_256x32.u_sram_256x32_562/L_HI
+ VDD VSS sg13cmos5l_tiehi
XFILLER_49_752 VDD VSS sg13cmos5l_decap_8
XFILLER_49_741 VDD VSS sg13cmos5l_fill_1
Xbank_A_sram.gen_ihp_256x32.u_sram_256x32_573 bank_A_sram.gen_ihp_256x32.u_sram_256x32_573/L_HI
+ VDD VSS sg13cmos5l_tiehi
XFILLER_76_560 VDD VSS sg13cmos5l_decap_8
XFILLER_37_914 VDD VSS sg13cmos5l_decap_8
XFILLER_48_251 VDD VSS sg13cmos5l_fill_2
XFILLER_64_733 VDD VSS sg13cmos5l_decap_8
XFILLER_36_479 VDD VSS sg13cmos5l_decap_8
XFILLER_63_232 VDD VSS sg13cmos5l_fill_1
X_4981_ _5041_/B _5044_/A _4981_/B VDD VSS sg13cmos5l_nor2_1
XFILLER_64_799 VDD VSS sg13cmos5l_fill_1
X_3932_ _3999_/B _3932_/A VDD VSS sg13cmos5l_buf_2
XFILLER_44_490 VDD VSS sg13cmos5l_decap_4
X_6720_ _7036_/A _6720_/A VDD VSS sg13cmos5l_buf_2
X_6651_ _6652_/A _6660_/B _6660_/A VDD VSS sg13cmos5l_nor2_1
X_6582_ _6771_/A _7692_/Q _6582_/B VDD VSS sg13cmos5l_xnor2_1
X_5602_ _5603_/A _5533_/B _5533_/A _5601_/Y VDD VSS sg13cmos5l_a21o_1
X_5533_ _5534_/B _5533_/A _5533_/B VDD VSS sg13cmos5l_xor2_1
XFILLER_11_18 VDD VSS sg13cmos5l_decap_8
X_5464_ _5512_/B _5586_/A _5464_/B VDD VSS sg13cmos5l_xnor2_1
X_7203_ _7217_/A _7536_/B _7203_/B _7537_/B VDD VSS sg13cmos5l_nand3_1
X_5395_ _5396_/C _5712_/A VDD VSS sg13cmos5l_inv_1
X_4415_ _4481_/A _4407_/B _4407_/A _4414_/X VDD VSS sg13cmos5l_a21o_1
Xfanout304 _5517_/A _3934_/A VDD VSS sg13cmos5l_buf_1
X_4346_ _4347_/A _4346_/A VDD VSS sg13cmos5l_inv_1
X_7134_ _7134_/Y _7134_/A _7134_/B VDD VSS sg13cmos5l_nand2_1
Xfanout348 _4738_/B1 _4205_/X VDD VSS sg13cmos5l_buf_2
Xfanout326 _5793_/A _5559_/A VDD VSS sg13cmos5l_buf_1
Xfanout315 _6114_/B _5755_/X VDD VSS sg13cmos5l_buf_1
Xfanout337 _5442_/A _5133_/A VDD VSS sg13cmos5l_buf_1
X_4277_ _4277_/Y _4277_/A _4277_/B VDD VSS sg13cmos5l_nor2_1
X_7065_ _7065_/X _7065_/A _7072_/B VDD VSS sg13cmos5l_and2_1
XFILLER_59_549 VDD VSS sg13cmos5l_decap_8
Xfanout359 _6720_/A _6951_/A VDD VSS sg13cmos5l_buf_4
X_6016_ _6017_/B _6016_/A _6018_/B VDD VSS sg13cmos5l_nand2_1
XFILLER_39_273 VDD VSS sg13cmos5l_decap_8
XFILLER_82_552 VDD VSS sg13cmos5l_decap_4
XFILLER_54_243 VDD VSS sg13cmos5l_fill_1
XFILLER_54_232 VDD VSS sg13cmos5l_decap_8
XFILLER_55_766 VDD VSS sg13cmos5l_decap_8
XFILLER_42_405 VDD VSS sg13cmos5l_fill_1
XFILLER_55_799 VDD VSS sg13cmos5l_decap_4
XFILLER_70_758 VDD VSS sg13cmos5l_fill_1
X_6918_ _6918_/Y _6754_/Y _6918_/B VDD VSS sg13cmos5l_nand2b_1
X_6849_ _6849_/X _6849_/A _6849_/B VDD VSS sg13cmos5l_and2_1
XFILLER_78_825 VDD VSS sg13cmos5l_fill_1
XFILLER_77_302 VDD VSS sg13cmos5l_decap_8
XFILLER_77_88 VDD VSS sg13cmos5l_decap_8
XFILLER_77_66 VDD VSS sg13cmos5l_fill_1
XFILLER_77_99 VDD VSS sg13cmos5l_fill_2
XFILLER_65_519 VDD VSS sg13cmos5l_fill_2
XFILLER_46_711 VDD VSS sg13cmos5l_fill_2
XFILLER_46_755 VDD VSS sg13cmos5l_decap_8
XFILLER_61_725 VDD VSS sg13cmos5l_fill_1
XFILLER_42_80 VDD VSS sg13cmos5l_decap_8
XFILLER_69_803 VDD VSS sg13cmos5l_decap_8
X_4200_ _6052_/A _4266_/A _4200_/B VDD VSS sg13cmos5l_nand2_1
X_5180_ _5181_/B _5245_/A _5180_/B VDD VSS sg13cmos5l_xnor2_1
X_4131_ _4132_/B _4310_/A _3950_/X _4262_/A _4530_/A VDD VSS sg13cmos5l_a22oi_1
XFILLER_68_324 VDD VSS sg13cmos5l_decap_8
X_4062_ _4063_/B _4079_/B _4079_/A VDD VSS sg13cmos5l_xor2_1
XFILLER_37_711 VDD VSS sg13cmos5l_fill_1
XFILLER_36_221 VDD VSS sg13cmos5l_decap_8
XFILLER_64_541 VDD VSS sg13cmos5l_decap_4
XFILLER_37_788 VDD VSS sg13cmos5l_fill_2
XFILLER_52_736 VDD VSS sg13cmos5l_decap_4
XFILLER_64_585 VDD VSS sg13cmos5l_decap_8
XFILLER_36_298 VDD VSS sg13cmos5l_decap_8
X_4964_ _4979_/A _4904_/B _4904_/A _4963_/X VDD VSS sg13cmos5l_a21o_1
XFILLER_51_224 VDD VSS sg13cmos5l_fill_1
XFILLER_51_246 VDD VSS sg13cmos5l_fill_2
X_6703_ _6703_/Y _6703_/A VDD VSS sg13cmos5l_inv_1
XFILLER_51_268 VDD VSS sg13cmos5l_decap_4
X_4895_ _4896_/B _4895_/A _4895_/B VDD VSS sg13cmos5l_xor2_1
X_7683_ _7683_/Q _7691_/CLK _7683_/D fanout384/X VDD VSS sg13cmos5l_dfrbpq_1
X_6634_ _6754_/A _7698_/Q _6634_/B VDD VSS sg13cmos5l_xnor2_1
XFILLER_22_17 VDD VSS sg13cmos5l_decap_8
XFILLER_22_28 VDD VSS sg13cmos5l_fill_1
X_6565_ _6567_/C _6576_/A _6565_/B _6565_/C VDD VSS sg13cmos5l_nand3_1
X_5516_ _5643_/A _5516_/A VDD VSS sg13cmos5l_buf_1
X_6496_ _6837_/B _6487_/B _7681_/Q VDD VSS sg13cmos5l_nand2b_1
X_5447_ _5447_/X _5447_/A VDD VSS sg13cmos5l_buf_1
X_5378_ _5378_/Y _5378_/A _5342_/B VDD VSS sg13cmos5l_nor2b_1
XFILLER_59_302 VDD VSS sg13cmos5l_fill_1
X_4329_ _4382_/A _4647_/B _4631_/A _4328_/Y VDD VSS sg13cmos5l_a21o_1
XFILLER_59_324 VDD VSS sg13cmos5l_decap_8
X_7117_ _7118_/B _7181_/A _7264_/B _7116_/Y VDD VSS sg13cmos5l_o21ai_1
XFILLER_74_305 VDD VSS sg13cmos5l_decap_8
X_7048_ _7484_/B _7483_/B VDD VSS sg13cmos5l_inv_2
XFILLER_47_25 VDD VSS sg13cmos5l_decap_8
XFILLER_47_508 VDD VSS sg13cmos5l_decap_8
Xfanout189 _6461_/C _6391_/X VDD VSS sg13cmos5l_buf_1
XFILLER_63_24 VDD VSS sg13cmos5l_decap_8
XFILLER_82_382 VDD VSS sg13cmos5l_decap_4
XFILLER_63_68 VDD VSS sg13cmos5l_fill_2
XFILLER_8_19 VDD VSS sg13cmos5l_decap_8
XFILLER_78_655 VDD VSS sg13cmos5l_fill_1
XFILLER_77_121 VDD VSS sg13cmos5l_fill_1
XFILLER_66_828 VDD VSS sg13cmos5l_decap_8
XFILLER_19_8 VDD VSS sg13cmos5l_decap_4
XFILLER_58_390 VDD VSS sg13cmos5l_decap_4
XFILLER_61_544 VDD VSS sg13cmos5l_decap_8
XFILLER_61_577 VDD VSS sg13cmos5l_fill_2
X_4680_ _4680_/X _4680_/A _4680_/B VDD VSS sg13cmos5l_and2_1
X_6350_ _6352_/A _6811_/B _6811_/A VDD VSS sg13cmos5l_nand2_2
X_5301_ _5357_/A _5301_/A _5294_/A VDD VSS sg13cmos5l_nor2b_1
X_6281_ _6586_/B _6303_/A _6448_/B VDD VSS sg13cmos5l_nand2_2
X_5232_ _5233_/B _5231_/B _5232_/B VDD VSS sg13cmos5l_nand2b_1
XFILLER_68_110 VDD VSS sg13cmos5l_decap_4
X_5163_ _5173_/A _5095_/B _5095_/A _5162_/X VDD VSS sg13cmos5l_a21o_1
X_4114_ _5977_/A _4207_/A _4114_/B VDD VSS sg13cmos5l_nand2_1
XFILLER_56_305 VDD VSS sg13cmos5l_decap_4
XFILLER_57_817 VDD VSS sg13cmos5l_decap_4
X_5094_ _5095_/B _5162_/B _5162_/A VDD VSS sg13cmos5l_xor2_1
X_4045_ _4046_/A _5898_/B _5897_/A VDD VSS sg13cmos5l_nor2b_1
XFILLER_17_17 VDD VSS sg13cmos5l_decap_8
XFILLER_17_28 VDD VSS sg13cmos5l_fill_1
XFILLER_65_861 VDD VSS sg13cmos5l_decap_8
Xbank_B_sram.gen_ihp_256x32.u_sram_256x32_609 bank_B_sram.gen_ihp_256x32.u_sram_256x32_609/L_HI
+ VDD VSS sg13cmos5l_tiehi
XFILLER_64_393 VDD VSS sg13cmos5l_decap_8
X_5996_ _5997_/A _6036_/A _5996_/B VDD VSS sg13cmos5l_xnor2_1
X_4947_ _4948_/B _5014_/A _4947_/B _4947_/C VDD VSS sg13cmos5l_nor3_1
XFILLER_33_27 VDD VSS sg13cmos5l_fill_2
XFILLER_52_588 VDD VSS sg13cmos5l_decap_8
X_7666_ _7666_/Q _7719_/CLK _7666_/D fanout389/X VDD VSS sg13cmos5l_dfrbpq_1
X_4878_ _4879_/B _4750_/X _5447_/A _5244_/B1 _5448_/A VDD VSS sg13cmos5l_a22oi_1
X_6617_ _6756_/A _7696_/Q _6617_/B VDD VSS sg13cmos5l_xnor2_1
X_7597_ _7599_/B _7597_/A _7597_/B VDD VSS sg13cmos5l_nand2_1
X_6548_ _6560_/A _6918_/B _7008_/B _6548_/C _6548_/D VDD VSS sg13cmos5l_nor4_1
X_6479_ _6841_/A _7680_/Q _6479_/B VDD VSS sg13cmos5l_xnor2_1
XFILLER_59_154 VDD VSS sg13cmos5l_fill_1
XFILLER_75_614 VDD VSS sg13cmos5l_decap_8
XFILLER_47_327 VDD VSS sg13cmos5l_decap_8
XFILLER_59_165 VDD VSS sg13cmos5l_fill_2
XFILLER_74_56 VDD VSS sg13cmos5l_decap_8
XFILLER_56_894 VDD VSS sg13cmos5l_decap_4
XFILLER_71_842 VDD VSS sg13cmos5l_fill_2
XFILLER_90_11 VDD VSS sg13cmos5l_decap_8
XFILLER_71_886 VDD VSS sg13cmos5l_decap_8
XFILLER_78_441 VDD VSS sg13cmos5l_decap_8
XFILLER_39_806 VDD VSS sg13cmos5l_fill_2
XFILLER_38_305 VDD VSS sg13cmos5l_fill_1
XFILLER_65_113 VDD VSS sg13cmos5l_decap_8
XFILLER_81_617 VDD VSS sg13cmos5l_decap_8
XFILLER_46_371 VDD VSS sg13cmos5l_decap_8
XFILLER_62_831 VDD VSS sg13cmos5l_fill_1
XFILLER_62_864 VDD VSS sg13cmos5l_decap_4
X_5850_ _5851_/B _5824_/B _5850_/B VDD VSS sg13cmos5l_nand2b_1
X_5781_ _5781_/X _5781_/A VDD VSS sg13cmos5l_buf_1
X_4801_ _4802_/B _5245_/A _4801_/B VDD VSS sg13cmos5l_xnor2_1
X_7520_ _7619_/C _7520_/A _7520_/B VDD VSS sg13cmos5l_xor2_1
X_4732_ _4732_/Y _4732_/A _4717_/B VDD VSS sg13cmos5l_nor2b_1
X_7451_ _7453_/B _7456_/A _7451_/B VDD VSS sg13cmos5l_xnor2_1
X_4663_ _4721_/A _4604_/B _4604_/A _4662_/X VDD VSS sg13cmos5l_a21o_1
X_6402_ _6403_/B _6410_/A _6401_/Y _6391_/X VDD VSS sg13cmos5l_o21ai_1
X_4594_ _4595_/B _4638_/A _4638_/B VDD VSS sg13cmos5l_xor2_1
X_7382_ _7382_/Y _7253_/Y _7394_/A2 _7343_/X VDD VSS sg13cmos5l_a21oi_1
X_6333_ _6630_/B _6977_/B _6979_/B _6355_/A VDD VSS sg13cmos5l_nand3_1
X_6264_ _6577_/B _6353_/A _6440_/A VDD VSS sg13cmos5l_nor2_1
X_5215_ _5216_/B _5215_/A _5287_/B VDD VSS sg13cmos5l_xor2_1
X_6195_ _6195_/Y _6195_/A VDD VSS sg13cmos5l_inv_1
X_5146_ _5147_/B _5460_/A _5206_/B _5146_/C VDD VSS sg13cmos5l_nor3_1
X_5077_ _5078_/B _5460_/A _5206_/B _5077_/C VDD VSS sg13cmos5l_nor3_1
XFILLER_57_669 VDD VSS sg13cmos5l_fill_1
X_4028_ _4223_/A _4090_/A VDD VSS sg13cmos5l_buf_1
XFILLER_71_138 VDD VSS sg13cmos5l_fill_1
XFILLER_52_352 VDD VSS sg13cmos5l_decap_4
XFILLER_53_864 VDD VSS sg13cmos5l_decap_4
XFILLER_53_886 VDD VSS sg13cmos5l_fill_1
XFILLER_100_21 VDD VSS sg13cmos5l_decap_8
X_5979_ _6025_/B _5977_/B _6111_/A _5977_/Y _5978_/Y VDD VSS sg13cmos5l_a22oi_1
XFILLER_40_525 VDD VSS sg13cmos5l_decap_8
XFILLER_40_536 VDD VSS sg13cmos5l_fill_2
X_7718_ _7718_/Q clkload7/A _7718_/D fanout393/X VDD VSS sg13cmos5l_dfrbpq_1
XFILLER_60_36 VDD VSS sg13cmos5l_decap_8
X_7649_ _7725_/D _7658_/B _7649_/B VDD VSS sg13cmos5l_nand2_2
XFILLER_60_47 VDD VSS sg13cmos5l_fill_1
XFILLER_114_4 VDD VSS sg13cmos5l_decap_8
XFILLER_79_205 VDD VSS sg13cmos5l_decap_8
XFILLER_85_22 VDD VSS sg13cmos5l_decap_8
XFILLER_75_455 VDD VSS sg13cmos5l_decap_8
XFILLER_75_444 VDD VSS sg13cmos5l_fill_1
XFILLER_75_433 VDD VSS sg13cmos5l_decap_8
XFILLER_44_875 VDD VSS sg13cmos5l_fill_1
XFILLER_55_190 VDD VSS sg13cmos5l_decap_8
XFILLER_71_672 VDD VSS sg13cmos5l_fill_2
XFILLER_43_385 VDD VSS sg13cmos5l_fill_2
XFILLER_70_182 VDD VSS sg13cmos5l_fill_2
Xrebuffer1208 _5170_/B _5169_/Y VDD VSS sg13cmos5l_buf_1
Xrebuffer1219 rebuffer1219/X rebuffer1220/X VDD VSS sg13cmos5l_buf_1
X_5000_ _5000_/X _5000_/A VDD VSS sg13cmos5l_buf_1
XFILLER_38_102 VDD VSS sg13cmos5l_decap_8
XFILLER_82_926 VDD VSS sg13cmos5l_decap_8
XFILLER_66_488 VDD VSS sg13cmos5l_fill_2
XFILLER_38_179 VDD VSS sg13cmos5l_decap_8
XFILLER_81_436 VDD VSS sg13cmos5l_decap_8
XFILLER_35_820 VDD VSS sg13cmos5l_decap_4
X_6951_ _6951_/Y _6951_/A _7138_/A VDD VSS sg13cmos5l_nor2_1
X_6882_ _6882_/Y _6882_/A _6882_/B VDD VSS sg13cmos5l_xnor2_1
X_5902_ _5904_/A _5944_/A _5902_/B VDD VSS sg13cmos5l_xnor2_1
XFILLER_14_18 VDD VSS sg13cmos5l_decap_8
X_5833_ _5837_/C _5833_/A _5833_/B VDD VSS sg13cmos5l_nand2_1
XFILLER_50_834 VDD VSS sg13cmos5l_fill_2
XFILLER_50_878 VDD VSS sg13cmos5l_decap_8
XFILLER_61_193 VDD VSS sg13cmos5l_decap_8
X_5764_ _5765_/B _5633_/X _5943_/A2 _5572_/X _5943_/B2 VDD VSS sg13cmos5l_a22oi_1
X_7503_ _7573_/B _7503_/A _7503_/B VDD VSS sg13cmos5l_xor2_1
X_5695_ _5742_/A _5649_/B _5649_/A _5694_/Y VDD VSS sg13cmos5l_a21oi_1
X_4715_ _4716_/B _4715_/A _4715_/B VDD VSS sg13cmos5l_nand2_1
X_4646_ _4647_/C _5000_/A VDD VSS sg13cmos5l_inv_1
XFILLER_30_17 VDD VSS sg13cmos5l_decap_8
XFILLER_30_28 VDD VSS sg13cmos5l_fill_1
X_7434_ _7583_/B _7434_/A _7434_/B VDD VSS sg13cmos5l_nand2_2
X_7365_ _7368_/B _7366_/A _7374_/A VDD VSS sg13cmos5l_xnor2_1
X_4577_ _4578_/B _4986_/B1 _4313_/X _4375_/X _4314_/X VDD VSS sg13cmos5l_a22oi_1
X_6316_ _6318_/A _6317_/A _6317_/C _7664_/Q VDD VSS sg13cmos5l_a21oi_1
X_7296_ _7297_/B _7296_/A _7296_/B VDD VSS sg13cmos5l_nor2_1
XFILLER_39_15 VDD VSS sg13cmos5l_decap_8
X_6247_ _7274_/A _6259_/A VDD VSS sg13cmos5l_inv_1
X_6178_ _6178_/Y _6178_/A _6169_/B VDD VSS sg13cmos5l_nor2b_1
X_5129_ _5130_/B _4872_/X _5568_/A _5370_/B1 _5569_/A VDD VSS sg13cmos5l_a22oi_1
XFILLER_52_160 VDD VSS sg13cmos5l_decap_8
XFILLER_71_35 VDD VSS sg13cmos5l_fill_1
Xrebuffer840 _6882_/B _6531_/A VDD VSS sg13cmos5l_buf_1
XFILLER_68_709 VDD VSS sg13cmos5l_fill_1
XFILLER_48_411 VDD VSS sg13cmos5l_fill_2
XFILLER_75_252 VDD VSS sg13cmos5l_fill_1
XFILLER_75_241 VDD VSS sg13cmos5l_decap_4
XFILLER_35_105 VDD VSS sg13cmos5l_fill_1
XFILLER_35_138 VDD VSS sg13cmos5l_fill_2
XFILLER_63_414 VDD VSS sg13cmos5l_decap_8
XFILLER_71_491 VDD VSS sg13cmos5l_fill_2
X_5480_ _5483_/B _5547_/A _5480_/B VDD VSS sg13cmos5l_xnor2_1
X_4500_ _4500_/X _4500_/A _4500_/B VDD VSS sg13cmos5l_and2_1
XANTENNA_1 input9/X VDD VSS sg13cmos5l_antennanp
X_4431_ _4432_/B _4738_/B1 _4996_/A _4675_/B1 _4997_/A VDD VSS sg13cmos5l_a22oi_1
X_7150_ _7651_/B _7150_/A _7150_/B VDD VSS sg13cmos5l_nand2_1
X_4362_ _4492_/A _4621_/A VDD VSS sg13cmos5l_inv_1
X_4293_ _4351_/B _4346_/A _4293_/B VDD VSS sg13cmos5l_xnor2_1
X_6101_ _6132_/A _6160_/B _6072_/B _6100_/Y VDD VSS sg13cmos5l_o21ai_1
X_7081_ _7081_/Y _7081_/A _7134_/B VDD VSS sg13cmos5l_nand2_1
X_6032_ _6068_/A _6032_/A _6051_/A VDD VSS sg13cmos5l_xor2_1
XFILLER_67_742 VDD VSS sg13cmos5l_fill_1
XFILLER_67_731 VDD VSS sg13cmos5l_fill_1
XFILLER_67_797 VDD VSS sg13cmos5l_decap_8
XFILLER_66_296 VDD VSS sg13cmos5l_fill_2
XFILLER_66_285 VDD VSS sg13cmos5l_decap_8
XFILLER_82_767 VDD VSS sg13cmos5l_fill_2
XFILLER_81_233 VDD VSS sg13cmos5l_decap_8
X_6934_ _7061_/A _6880_/Y _6883_/Y _6941_/B VDD VSS sg13cmos5l_mux2_1
XFILLER_41_108 VDD VSS sg13cmos5l_decap_8
XFILLER_35_683 VDD VSS sg13cmos5l_fill_1
X_6865_ _6865_/Y _6941_/B _6929_/A VDD VSS sg13cmos5l_nor2_1
X_5816_ _5855_/B _5816_/A _5816_/B VDD VSS sg13cmos5l_xor2_1
X_6796_ _6796_/X _6937_/A VDD VSS sg13cmos5l_buf_1
X_5747_ _5748_/B _5793_/A _5747_/B VDD VSS sg13cmos5l_xnor2_1
X_7417_ _7579_/A _7424_/A _7417_/B VDD VSS sg13cmos5l_xnor2_1
X_5678_ _5679_/B _5656_/A _5656_/B _5657_/A VDD VSS sg13cmos5l_o21ai_1
X_4629_ _4630_/B _4920_/B1 _4996_/A _4859_/B1 _4997_/A VDD VSS sg13cmos5l_a22oi_1
X_7348_ _7355_/A _7348_/A _7518_/B _7519_/B VDD VSS sg13cmos5l_nand3_1
X_7279_ _7279_/Y _7277_/Y _7278_/Y _6259_/X VDD VSS sg13cmos5l_a21oi_1
XFILLER_49_208 VDD VSS sg13cmos5l_decap_8
XFILLER_49_219 VDD VSS sg13cmos5l_fill_1
XFILLER_58_753 VDD VSS sg13cmos5l_fill_1
XFILLER_58_731 VDD VSS sg13cmos5l_decap_4
XFILLER_58_775 VDD VSS sg13cmos5l_fill_1
XFILLER_57_274 VDD VSS sg13cmos5l_decap_8
XFILLER_82_23 VDD VSS sg13cmos5l_decap_8
XFILLER_82_12 VDD VSS sg13cmos5l_fill_1
XFILLER_72_255 VDD VSS sg13cmos5l_fill_1
XFILLER_61_907 VDD VSS sg13cmos5l_fill_1
XFILLER_82_45 VDD VSS sg13cmos5l_decap_8
XFILLER_73_789 VDD VSS sg13cmos5l_decap_4
XFILLER_82_78 VDD VSS sg13cmos5l_decap_4
XFILLER_41_620 VDD VSS sg13cmos5l_fill_2
Xrebuffer692 rebuffer692/X rebuffer693/X VDD VSS sg13cmos5l_buf_1
Xrebuffer670 _6861_/A _6564_/A VDD VSS sg13cmos5l_buf_1
Xrebuffer681 _6852_/A1 _6436_/A VDD VSS sg13cmos5l_buf_1
Xbank_A_sram.gen_ihp_256x32.u_sram_256x32_552 bank_A_sram.gen_ihp_256x32.u_sram_256x32/A_BM[4]
+ VDD VSS sg13cmos5l_tiehi
Xbank_A_sram.gen_ihp_256x32.u_sram_256x32_563 bank_A_sram.gen_ihp_256x32.u_sram_256x32_563/L_HI
+ VDD VSS sg13cmos5l_tiehi
Xbank_A_sram.gen_ihp_256x32.u_sram_256x32_574 bank_A_sram.gen_ihp_256x32.u_sram_256x32_574/L_HI
+ VDD VSS sg13cmos5l_tiehi
XFILLER_48_230 VDD VSS sg13cmos5l_decap_8
XFILLER_49_764 VDD VSS sg13cmos5l_decap_8
XFILLER_48_263 VDD VSS sg13cmos5l_fill_1
XFILLER_64_723 VDD VSS sg13cmos5l_fill_1
XFILLER_36_469 VDD VSS sg13cmos5l_decap_8
XFILLER_36_447 VDD VSS sg13cmos5l_fill_2
X_4980_ _5040_/B _4980_/A _4980_/B VDD VSS sg13cmos5l_nand2_1
XFILLER_51_417 VDD VSS sg13cmos5l_decap_4
X_3931_ _3934_/A _3931_/A VDD VSS sg13cmos5l_buf_1
XFILLER_63_299 VDD VSS sg13cmos5l_fill_2
X_6650_ _6660_/A _6646_/Y _6656_/A _6684_/C VDD VSS sg13cmos5l_o21ai_1
X_6581_ _6582_/B _6578_/Y _6588_/A _6527_/X VDD VSS sg13cmos5l_o21ai_1
X_5601_ _5601_/Y _5601_/A _5534_/B VDD VSS sg13cmos5l_nor2b_1
X_5532_ _5533_/B _5532_/A _5532_/B VDD VSS sg13cmos5l_nand2_1
X_5463_ _5464_/B _5698_/A _5644_/A2 _5633_/A _5644_/B2 VDD VSS sg13cmos5l_a22oi_1
X_5394_ _5397_/A _5517_/A _5712_/A _5519_/B VDD VSS sg13cmos5l_a21oi_1
X_7202_ _7537_/B _7175_/B _7719_/Q VDD VSS sg13cmos5l_nand2b_1
X_4414_ _4414_/X _4414_/A _4414_/B VDD VSS sg13cmos5l_and2_1
Xfanout305 _7307_/B _7324_/B VDD VSS sg13cmos5l_buf_1
X_4345_ _4354_/B _4345_/A _4292_/B VDD VSS sg13cmos5l_nor2b_1
X_7133_ _7294_/A _7164_/A _6932_/Y _7132_/Y VDD VSS sg13cmos5l_o21ai_1
Xfanout316 _6082_/A1 _5712_/X VDD VSS sg13cmos5l_buf_1
XFILLER_59_528 VDD VSS sg13cmos5l_decap_8
XFILLER_59_517 VDD VSS sg13cmos5l_fill_1
Xfanout327 _5745_/B1 _5190_/X VDD VSS sg13cmos5l_buf_1
Xfanout338 _5370_/B1 _4811_/X VDD VSS sg13cmos5l_buf_1
X_4276_ _4277_/B _4276_/A _4327_/B _4276_/C VDD VSS sg13cmos5l_nor3_1
Xfanout349 _4675_/B1 _4155_/X VDD VSS sg13cmos5l_buf_2
X_7064_ _7112_/B _7080_/A VDD VSS sg13cmos5l_buf_1
X_6015_ _6018_/B _6015_/A _6015_/B VDD VSS sg13cmos5l_nand2_1
XFILLER_39_252 VDD VSS sg13cmos5l_decap_8
XFILLER_67_583 VDD VSS sg13cmos5l_decap_8
XFILLER_70_704 VDD VSS sg13cmos5l_decap_8
XFILLER_43_907 VDD VSS sg13cmos5l_decap_4
XFILLER_55_745 VDD VSS sg13cmos5l_fill_1
XFILLER_82_586 VDD VSS sg13cmos5l_decap_4
XFILLER_82_575 VDD VSS sg13cmos5l_decap_8
XFILLER_42_428 VDD VSS sg13cmos5l_decap_8
XFILLER_43_929 VDD VSS sg13cmos5l_decap_4
XFILLER_54_255 VDD VSS sg13cmos5l_decap_4
X_6917_ _6917_/Y _6915_/Y _6917_/B VDD VSS sg13cmos5l_nand2b_1
XFILLER_52_26 VDD VSS sg13cmos5l_fill_2
X_6848_ _6849_/A _6848_/A _6848_/B VDD VSS sg13cmos5l_xor2_1
X_6779_ _6899_/B _6779_/A _6779_/B VDD VSS sg13cmos5l_nand2_2
XFILLER_78_804 VDD VSS sg13cmos5l_fill_1
XFILLER_58_550 VDD VSS sg13cmos5l_decap_8
XFILLER_93_22 VDD VSS sg13cmos5l_decap_8
XFILLER_45_200 VDD VSS sg13cmos5l_fill_1
XFILLER_58_594 VDD VSS sg13cmos5l_decap_8
XFILLER_46_745 VDD VSS sg13cmos5l_fill_2
XFILLER_46_767 VDD VSS sg13cmos5l_decap_8
XFILLER_46_778 VDD VSS sg13cmos5l_fill_1
XFILLER_60_247 VDD VSS sg13cmos5l_fill_1
X_4130_ _4165_/A _3956_/X _4375_/A _4129_/Y VDD VSS sg13cmos5l_a21o_1
XFILLER_69_837 VDD VSS sg13cmos5l_decap_8
X_4061_ _4079_/B _4528_/A _4061_/B VDD VSS sg13cmos5l_xnor2_1
XFILLER_56_509 VDD VSS sg13cmos5l_fill_1
XFILLER_36_200 VDD VSS sg13cmos5l_decap_8
XFILLER_76_391 VDD VSS sg13cmos5l_fill_1
XFILLER_36_277 VDD VSS sg13cmos5l_decap_8
XFILLER_52_715 VDD VSS sg13cmos5l_decap_8
X_4963_ _4963_/X _4963_/A _4963_/B VDD VSS sg13cmos5l_and2_1
X_7682_ _7682_/Q clkload0/A _7682_/D fanout383/X VDD VSS sg13cmos5l_dfrbpq_1
X_6702_ _6702_/Y _6702_/A VDD VSS sg13cmos5l_inv_1
X_4894_ _4895_/B _4939_/A _4939_/B VDD VSS sg13cmos5l_xor2_1
X_6633_ _6634_/B _6647_/A _6632_/Y _6641_/C VDD VSS sg13cmos5l_o21ai_1
XFILLER_60_770 VDD VSS sg13cmos5l_fill_1
X_6564_ _6573_/A _6564_/A _6860_/B _6861_/B VDD VSS sg13cmos5l_nand3_1
X_5515_ _5525_/A _5810_/B _5515_/B VDD VSS sg13cmos5l_xnor2_1
X_6495_ _6836_/A _6495_/A VDD VSS sg13cmos5l_inv_1
X_5446_ _5977_/B _5446_/A VDD VSS sg13cmos5l_buf_1
X_5377_ _5471_/B _5377_/A _5377_/B VDD VSS sg13cmos5l_xor2_1
X_4328_ _4328_/Y _4328_/A _4328_/B VDD VSS sg13cmos5l_nor2_1
X_7116_ _7116_/Y _7114_/Y _7115_/Y _7091_/A VDD VSS sg13cmos5l_a21oi_1
X_7047_ _7047_/Y _7085_/B _6903_/Y _7046_/Y VDD VSS sg13cmos5l_o21ai_1
X_4259_ _4430_/A _4259_/A VDD VSS sg13cmos5l_buf_1
XFILLER_47_59 VDD VSS sg13cmos5l_decap_8
XFILLER_82_372 VDD VSS sg13cmos5l_fill_2
XFILLER_43_715 VDD VSS sg13cmos5l_fill_2
XFILLER_55_575 VDD VSS sg13cmos5l_fill_2
XFILLER_70_545 VDD VSS sg13cmos5l_decap_8
XFILLER_88_11 VDD VSS sg13cmos5l_decap_8
XFILLER_78_667 VDD VSS sg13cmos5l_decap_4
XFILLER_59_881 VDD VSS sg13cmos5l_decap_8
XFILLER_46_542 VDD VSS sg13cmos5l_decap_4
XFILLER_37_81 VDD VSS sg13cmos5l_decap_8
XFILLER_53_91 VDD VSS sg13cmos5l_decap_4
X_5300_ _7686_/D _5360_/B _5360_/A VDD VSS sg13cmos5l_xor2_1
X_6280_ _6448_/B _6354_/A _6355_/A _6517_/C VDD VSS sg13cmos5l_nor3_1
X_5231_ _5233_/A _5232_/B _5231_/B VDD VSS sg13cmos5l_nand2b_1
XFILLER_45_2 VDD VSS sg13cmos5l_fill_1
X_5162_ _5162_/X _5162_/A _5162_/B VDD VSS sg13cmos5l_and2_1
X_4113_ _5978_/B _4113_/A _4114_/B VDD VSS sg13cmos5l_nor2_1
X_5093_ _5162_/A _5091_/Y _5024_/B _5092_/Y VDD VSS sg13cmos5l_o21ai_1
X_4044_ _5897_/A _4168_/A _4044_/B VDD VSS sg13cmos5l_nand2_1
XFILLER_68_199 VDD VSS sg13cmos5l_decap_8
XFILLER_37_542 VDD VSS sg13cmos5l_decap_8
XFILLER_49_391 VDD VSS sg13cmos5l_fill_1
XFILLER_56_339 VDD VSS sg13cmos5l_fill_2
XFILLER_64_361 VDD VSS sg13cmos5l_fill_1
XFILLER_64_372 VDD VSS sg13cmos5l_decap_8
XFILLER_64_383 VDD VSS sg13cmos5l_fill_2
X_5995_ _5996_/B _6037_/A _6037_/B VDD VSS sg13cmos5l_xor2_1
X_4946_ _4947_/C _5269_/A VDD VSS sg13cmos5l_inv_1
X_7665_ _7665_/Q clkload7/A _7665_/D fanout389/X VDD VSS sg13cmos5l_dfrbpq_1
X_4877_ _4877_/X _4877_/A VDD VSS sg13cmos5l_buf_1
X_6616_ _6617_/B _6612_/Y _6623_/A _6641_/C VDD VSS sg13cmos5l_o21ai_1
X_7596_ _7600_/A _7596_/A _7596_/B _7629_/C VDD VSS sg13cmos5l_nor3_2
X_6547_ _6555_/A _6547_/A _6869_/A _6870_/B VDD VSS sg13cmos5l_nand3_1
X_6478_ _6479_/B _6475_/Y _6485_/B _6459_/X VDD VSS sg13cmos5l_o21ai_1
X_5429_ _5437_/A _5373_/B _5302_/A _5429_/S VDD VSS sg13cmos5l_mux2_1
XFILLER_74_24 VDD VSS sg13cmos5l_decap_8
XFILLER_56_840 VDD VSS sg13cmos5l_decap_4
XFILLER_74_35 VDD VSS sg13cmos5l_fill_1
XFILLER_56_862 VDD VSS sg13cmos5l_decap_8
XFILLER_82_180 VDD VSS sg13cmos5l_decap_8
XFILLER_43_534 VDD VSS sg13cmos5l_decap_8
XFILLER_70_397 VDD VSS sg13cmos5l_decap_4
XFILLER_78_431 VDD VSS sg13cmos5l_decap_4
XFILLER_74_670 VDD VSS sg13cmos5l_fill_1
XFILLER_47_862 VDD VSS sg13cmos5l_decap_8
XFILLER_47_873 VDD VSS sg13cmos5l_fill_2
XFILLER_46_394 VDD VSS sg13cmos5l_fill_1
XFILLER_62_843 VDD VSS sg13cmos5l_decap_4
X_4800_ _4801_/B _4986_/B1 _4563_/X _4920_/B1 _4564_/X VDD VSS sg13cmos5l_a22oi_1
XFILLER_61_331 VDD VSS sg13cmos5l_fill_1
X_5780_ _5845_/B _5788_/A _5780_/B VDD VSS sg13cmos5l_xnor2_1
XFILLER_61_364 VDD VSS sg13cmos5l_decap_8
X_4731_ _4784_/A _4731_/A _4720_/A VDD VSS sg13cmos5l_nor2b_1
X_7450_ _7451_/B _7211_/Y _7397_/A _7399_/A VDD VSS sg13cmos5l_a21o_1
X_4662_ _4662_/X _4662_/A _4662_/B VDD VSS sg13cmos5l_and2_1
X_6401_ _6401_/Y _6401_/A _6401_/B VDD VSS sg13cmos5l_nor2_1
X_4593_ _4638_/B _5080_/A _4593_/B VDD VSS sg13cmos5l_xnor2_1
X_7381_ _7386_/A _7381_/A _7381_/B _7506_/A VDD VSS sg13cmos5l_nand3_1
X_6332_ _7091_/A _6785_/A VDD VSS sg13cmos5l_inv_1
X_6263_ _6440_/A _6356_/A _6354_/A _6516_/A VDD VSS sg13cmos5l_nand3_1
X_5214_ _5287_/B _5214_/A _5214_/B VDD VSS sg13cmos5l_xor2_1
X_6194_ _6194_/Y _6209_/A1 _6192_/Y _6193_/Y VDD VSS sg13cmos5l_a21oi_1
X_5145_ _5146_/C _5505_/A VDD VSS sg13cmos5l_inv_1
XFILLER_28_17 VDD VSS sg13cmos5l_fill_2
X_5076_ _5077_/C _5443_/A VDD VSS sg13cmos5l_inv_1
XFILLER_56_147 VDD VSS sg13cmos5l_decap_8
X_4027_ _4090_/A _4027_/A VDD VSS sg13cmos5l_inv_1
XFILLER_71_106 VDD VSS sg13cmos5l_fill_1
XFILLER_38_851 VDD VSS sg13cmos5l_decap_8
XFILLER_37_350 VDD VSS sg13cmos5l_decap_8
XFILLER_56_169 VDD VSS sg13cmos5l_decap_8
XFILLER_37_394 VDD VSS sg13cmos5l_fill_2
XFILLER_53_843 VDD VSS sg13cmos5l_decap_4
XFILLER_53_876 VDD VSS sg13cmos5l_decap_4
X_5978_ _5978_/Y _6111_/A _5978_/B VDD VSS sg13cmos5l_nor2_1
XFILLER_52_386 VDD VSS sg13cmos5l_fill_1
X_4929_ _4956_/A _4897_/B _4897_/A _4928_/Y VDD VSS sg13cmos5l_a21oi_1
X_7717_ _7717_/Q clkload0/A _7717_/D fanout382/X VDD VSS sg13cmos5l_dfrbpq_1
XFILLER_52_397 VDD VSS sg13cmos5l_fill_1
X_7648_ _7649_/B _7657_/A _7648_/B VDD VSS sg13cmos5l_nand2_2
X_7579_ _7623_/A _7579_/A _7579_/B VDD VSS sg13cmos5l_xor2_1
XFILLER_47_103 VDD VSS sg13cmos5l_decap_8
XFILLER_63_629 VDD VSS sg13cmos5l_decap_8
XFILLER_62_106 VDD VSS sg13cmos5l_fill_2
XFILLER_62_128 VDD VSS sg13cmos5l_decap_8
XFILLER_55_180 VDD VSS sg13cmos5l_fill_2
XFILLER_43_364 VDD VSS sg13cmos5l_fill_1
XFILLER_44_887 VDD VSS sg13cmos5l_decap_4
Xrebuffer1209 _4014_/A _4015_/A VDD VSS sg13cmos5l_buf_2
XFILLER_22_4 VDD VSS sg13cmos5l_decap_8
XFILLER_78_283 VDD VSS sg13cmos5l_decap_8
XFILLER_66_445 VDD VSS sg13cmos5l_decap_4
XFILLER_38_158 VDD VSS sg13cmos5l_decap_8
X_6950_ _7138_/A _7065_/A _6943_/A _6949_/X VDD VSS sg13cmos5l_a21oi_1
XFILLER_81_415 VDD VSS sg13cmos5l_decap_8
XFILLER_47_670 VDD VSS sg13cmos5l_decap_4
XFILLER_47_692 VDD VSS sg13cmos5l_fill_1
X_5901_ _5902_/B _6114_/B _5943_/A2 _6082_/A1 _5943_/B2 VDD VSS sg13cmos5l_a22oi_1
X_6881_ _7032_/A _6879_/Y _6880_/Y _6939_/A VDD VSS sg13cmos5l_mux2_1
X_5832_ _5837_/B _5928_/A VDD VSS sg13cmos5l_inv_1
XFILLER_61_150 VDD VSS sg13cmos5l_fill_1
XFILLER_62_695 VDD VSS sg13cmos5l_decap_8
X_5763_ _5797_/A _5870_/A _5763_/B VDD VSS sg13cmos5l_xnor2_1
XFILLER_50_857 VDD VSS sg13cmos5l_decap_8
X_7502_ _7503_/B _7572_/A _7571_/A _7413_/A VDD VSS sg13cmos5l_o21ai_1
X_4714_ _4715_/B _4656_/A _4714_/B VDD VSS sg13cmos5l_nand2b_1
X_5694_ _5694_/Y _5694_/A _5694_/B VDD VSS sg13cmos5l_nor2_1
X_4645_ _4648_/A _3930_/X _5000_/A _4387_/X VDD VSS sg13cmos5l_a21oi_1
X_7433_ _7434_/A _7429_/B _7426_/B _7464_/B VDD VSS sg13cmos5l_a21o_1
X_7364_ _7374_/A _7289_/A _7211_/Y _7363_/Y VDD VSS sg13cmos5l_o21ai_1
X_4576_ _4623_/A _4576_/A _4576_/B VDD VSS sg13cmos5l_xnor2_1
X_6315_ _6317_/A _6324_/B _6324_/A VDD VSS sg13cmos5l_xnor2_1
X_7295_ _7295_/Y _7129_/B _7276_/S _7294_/X VDD VSS sg13cmos5l_a21oi_1
X_6246_ _6259_/A _7712_/Q VDD VSS sg13cmos5l_buf_2
X_6177_ _6180_/B _6177_/A _6177_/B VDD VSS sg13cmos5l_xnor2_1
X_5128_ _5155_/A _5088_/B _5088_/A _5127_/Y VDD VSS sg13cmos5l_a21oi_1
XFILLER_73_905 VDD VSS sg13cmos5l_fill_1
XFILLER_55_15 VDD VSS sg13cmos5l_fill_2
XFILLER_38_681 VDD VSS sg13cmos5l_fill_2
X_5059_ _5089_/A _5022_/B _5022_/A _5058_/Y VDD VSS sg13cmos5l_a21oi_1
XFILLER_40_301 VDD VSS sg13cmos5l_fill_1
XFILLER_41_846 VDD VSS sg13cmos5l_decap_8
XFILLER_53_695 VDD VSS sg13cmos5l_decap_4
Xrebuffer841 _6721_/B _6686_/A VDD VSS sg13cmos5l_buf_1
XFILLER_96_11 VDD VSS sg13cmos5l_decap_8
XFILLER_49_902 VDD VSS sg13cmos5l_decap_8
XFILLER_76_721 VDD VSS sg13cmos5l_fill_1
XFILLER_63_437 VDD VSS sg13cmos5l_fill_2
XFILLER_44_651 VDD VSS sg13cmos5l_decap_8
XANTENNA_2 input20/X VDD VSS sg13cmos5l_antennanp
X_4430_ _4430_/X _4430_/A VDD VSS sg13cmos5l_buf_1
X_6100_ _6100_/Y _6100_/A _6100_/B VDD VSS sg13cmos5l_nand2_1
X_4361_ _4676_/A quant_cfg[13] VDD VSS sg13cmos5l_buf_1
X_4292_ _4346_/A _4345_/A _4292_/B VDD VSS sg13cmos5l_xnor2_1
X_7080_ _7138_/B _7080_/A VDD VSS sg13cmos5l_buf_1
XFILLER_67_710 VDD VSS sg13cmos5l_decap_4
X_6031_ _6051_/A _6031_/A _6031_/B VDD VSS sg13cmos5l_xnor2_1
XFILLER_81_212 VDD VSS sg13cmos5l_decap_8
XFILLER_54_404 VDD VSS sg13cmos5l_fill_1
X_6933_ _7072_/A _6882_/Y _6874_/B _6957_/S VDD VSS sg13cmos5l_mux2_1
XFILLER_81_289 VDD VSS sg13cmos5l_decap_8
XFILLER_35_673 VDD VSS sg13cmos5l_fill_2
X_6864_ _6929_/A _6864_/A _6861_/A VDD VSS sg13cmos5l_nor2b_1
X_5815_ _5816_/B _5876_/B _5876_/A VDD VSS sg13cmos5l_xor2_1
XFILLER_50_621 VDD VSS sg13cmos5l_decap_4
X_6795_ _6797_/A _7004_/A _6789_/Y _6794_/Y VDD VSS sg13cmos5l_o21ai_1
X_5746_ _5747_/B _5909_/B1 _6027_/A2 _5859_/B1 _6027_/B2 VDD VSS sg13cmos5l_a22oi_1
X_5677_ _5679_/A _5658_/A _5677_/B VDD VSS sg13cmos5l_nand2b_1
X_4628_ _4656_/A _4597_/B _4597_/A _4627_/Y VDD VSS sg13cmos5l_a21oi_1
X_7416_ _7417_/B _7404_/X _7312_/Y _7399_/Y VDD VSS sg13cmos5l_o21ai_1
X_7347_ _7519_/B _7347_/A _7347_/B VDD VSS sg13cmos5l_nand2_1
X_4559_ _4662_/B _4557_/Y _4538_/B _4558_/Y VDD VSS sg13cmos5l_o21ai_1
X_7278_ _7278_/Y _7186_/A _7248_/X _7297_/A VDD VSS sg13cmos5l_a21oi_1
XFILLER_77_518 VDD VSS sg13cmos5l_fill_2
XFILLER_77_507 VDD VSS sg13cmos5l_fill_2
X_6229_ _6704_/A _7706_/Q VDD VSS sg13cmos5l_buf_1
XFILLER_58_721 VDD VSS sg13cmos5l_fill_1
XFILLER_57_242 VDD VSS sg13cmos5l_fill_2
XFILLER_57_231 VDD VSS sg13cmos5l_decap_8
XFILLER_73_746 VDD VSS sg13cmos5l_fill_2
XFILLER_53_492 VDD VSS sg13cmos5l_decap_8
XFILLER_40_197 VDD VSS sg13cmos5l_decap_8
Xrebuffer660 rebuffer660/X rebuffer661/X VDD VSS sg13cmos5l_buf_1
Xrebuffer682 rebuffer682/X _7348_/A VDD VSS sg13cmos5l_buf_1
Xrebuffer693 rebuffer693/X rebuffer767/X VDD VSS sg13cmos5l_buf_1
Xrebuffer671 _6723_/B _6678_/A VDD VSS sg13cmos5l_buf_1
Xbank_A_sram.gen_ihp_256x32.u_sram_256x32_553 bank_A_sram.gen_ihp_256x32.u_sram_256x32/A_BM[5]
+ VDD VSS sg13cmos5l_tiehi
XFILLER_49_721 VDD VSS sg13cmos5l_fill_1
XFILLER_49_732 VDD VSS sg13cmos5l_decap_8
Xbank_A_sram.gen_ihp_256x32.u_sram_256x32_564 bank_A_sram.gen_ihp_256x32.u_sram_256x32_564/L_HI
+ VDD VSS sg13cmos5l_tiehi
Xbank_A_sram.gen_ihp_256x32.u_sram_256x32_575 bank_A_sram.gen_ihp_256x32.u_sram_256x32_575/L_HI
+ VDD VSS sg13cmos5l_tiehi
XFILLER_76_595 VDD VSS sg13cmos5l_decap_8
XFILLER_36_426 VDD VSS sg13cmos5l_decap_8
XFILLER_56_80 VDD VSS sg13cmos5l_decap_8
XFILLER_63_223 VDD VSS sg13cmos5l_decap_8
X_3930_ _3930_/X _3972_/A VDD VSS sg13cmos5l_buf_1
XFILLER_51_429 VDD VSS sg13cmos5l_decap_4
Xbank_B_sram.gen_ihp_256x32.u_sram_256x32_590 bank_B_sram.gen_ihp_256x32.u_sram_256x32/A_BM[8]
+ VDD VSS sg13cmos5l_tiehi
X_6580_ _6588_/A _6587_/B VDD VSS sg13cmos5l_inv_1
X_5600_ _5606_/B _5600_/A VDD VSS sg13cmos5l_inv_1
X_5531_ _5532_/B _5469_/A _5531_/B VDD VSS sg13cmos5l_nand2b_1
X_5462_ _5512_/A _5460_/B _5712_/A _5461_/Y VDD VSS sg13cmos5l_a21o_1
X_7201_ _7536_/B _7201_/A _7215_/A VDD VSS sg13cmos5l_nand2_1
X_5393_ _5712_/A _5393_/A VDD VSS sg13cmos5l_buf_1
X_4413_ _7672_/D _4475_/B _4475_/A VDD VSS sg13cmos5l_xor2_1
X_7132_ _7132_/Y _7132_/A _7164_/A VDD VSS sg13cmos5l_nand2_1
X_4344_ _4411_/B _4355_/A _4343_/Y VDD VSS sg13cmos5l_nor2b_1
Xfanout317 _6082_/B1 _5698_/X VDD VSS sg13cmos5l_buf_1
X_7063_ _7063_/Y _7063_/A _7063_/B VDD VSS sg13cmos5l_nand2_1
Xfanout328 _5684_/B1 _5131_/X VDD VSS sg13cmos5l_buf_1
Xfanout306 _6913_/B _6976_/B VDD VSS sg13cmos5l_buf_1
Xfanout339 _5310_/B1 _4750_/X VDD VSS sg13cmos5l_buf_1
X_4275_ _4276_/C _4631_/A VDD VSS sg13cmos5l_inv_1
X_6014_ _6017_/A _6018_/C _6046_/B VDD VSS sg13cmos5l_nand2_1
XFILLER_39_231 VDD VSS sg13cmos5l_decap_8
XFILLER_82_543 VDD VSS sg13cmos5l_fill_1
XFILLER_36_39 VDD VSS sg13cmos5l_decap_8
XFILLER_55_779 VDD VSS sg13cmos5l_decap_8
X_6916_ _6917_/B _6753_/Y _6941_/B VDD VSS sg13cmos5l_nand2b_1
XFILLER_51_930 VDD VSS sg13cmos5l_decap_4
XFILLER_50_451 VDD VSS sg13cmos5l_fill_1
XFILLER_52_38 VDD VSS sg13cmos5l_decap_4
X_6847_ _6945_/A _6847_/A _6847_/B VDD VSS sg13cmos5l_xor2_1
X_6778_ _6784_/A _7311_/A _7111_/A _7311_/B VDD VSS sg13cmos5l_nand3_1
X_5729_ _5731_/C _5781_/A _5729_/B VDD VSS sg13cmos5l_xnor2_1
XFILLER_117_20 VDD VSS sg13cmos5l_decap_8
XFILLER_77_24 VDD VSS sg13cmos5l_decap_8
XFILLER_45_256 VDD VSS sg13cmos5l_fill_1
XFILLER_61_716 VDD VSS sg13cmos5l_decap_8
XFILLER_41_473 VDD VSS sg13cmos5l_fill_2
X_4060_ _4061_/B _4205_/A _3950_/A _4155_/A _3981_/A VDD VSS sg13cmos5l_a22oi_1
XFILLER_68_348 VDD VSS sg13cmos5l_decap_8
XFILLER_49_540 VDD VSS sg13cmos5l_decap_8
Xbank_A_sram.gen_ihp_256x32.u_sram_256x32_394 bank_A_sram.gen_ihp_256x32.u_sram_256x32_394/L_LO
+ VDD VSS sg13cmos5l_tielo
XFILLER_36_256 VDD VSS sg13cmos5l_decap_8
XFILLER_64_565 VDD VSS sg13cmos5l_decap_4
X_4962_ _4979_/B _4962_/A _4962_/B VDD VSS sg13cmos5l_xor2_1
XFILLER_51_215 VDD VSS sg13cmos5l_decap_8
X_4893_ _4939_/B _5080_/A _4893_/B VDD VSS sg13cmos5l_xnor2_1
X_7681_ _7681_/Q _7691_/CLK _7681_/D fanout384/X VDD VSS sg13cmos5l_dfrbpq_1
X_6701_ _6702_/A _6704_/A _6703_/A VDD VSS sg13cmos5l_nor2_1
X_6632_ _6632_/Y _6632_/A _6631_/A VDD VSS sg13cmos5l_nor2b_1
X_6563_ _6860_/B _6571_/B _7690_/Q VDD VSS sg13cmos5l_nand2_1
X_5514_ _5515_/B _5633_/A _5756_/A2 _5572_/A _5756_/B2 VDD VSS sg13cmos5l_a22oi_1
X_6494_ _6495_/A _6504_/B _6504_/A VDD VSS sg13cmos5l_nor2_1
X_5445_ _5497_/A _5870_/A _5445_/B VDD VSS sg13cmos5l_xnor2_1
X_5376_ _5377_/B _5376_/A _5427_/A VDD VSS sg13cmos5l_xnor2_1
X_7115_ _7115_/Y _6797_/A _7162_/B _6809_/X VDD VSS sg13cmos5l_a21oi_1
X_4327_ _4328_/B _4525_/A _4327_/B _4327_/C VDD VSS sg13cmos5l_nor3_1
X_7046_ _7046_/Y _7046_/A _7085_/B VDD VSS sg13cmos5l_nand2_1
X_4258_ _4259_/A _4508_/A _6052_/A _4257_/Y VDD VSS sg13cmos5l_o21ai_1
XFILLER_68_893 VDD VSS sg13cmos5l_fill_2
XFILLER_103_11 VDD VSS sg13cmos5l_decap_8
X_4189_ _4189_/Y _4189_/A _4143_/B VDD VSS sg13cmos5l_nor2b_1
XFILLER_55_532 VDD VSS sg13cmos5l_decap_4
XFILLER_70_513 VDD VSS sg13cmos5l_decap_4
XFILLER_42_226 VDD VSS sg13cmos5l_decap_8
XFILLER_70_579 VDD VSS sg13cmos5l_decap_4
XFILLER_78_646 VDD VSS sg13cmos5l_decap_8
XFILLER_66_819 VDD VSS sg13cmos5l_fill_1
XFILLER_59_860 VDD VSS sg13cmos5l_decap_8
XFILLER_37_60 VDD VSS sg13cmos5l_decap_8
XFILLER_74_863 VDD VSS sg13cmos5l_fill_2
XFILLER_46_565 VDD VSS sg13cmos5l_fill_1
XFILLER_73_384 VDD VSS sg13cmos5l_fill_2
XFILLER_41_292 VDD VSS sg13cmos5l_fill_1
X_5230_ _5231_/B _5230_/A _5230_/B VDD VSS sg13cmos5l_nor2_1
XFILLER_69_613 VDD VSS sg13cmos5l_fill_1
X_5161_ _5173_/B _5222_/A _5161_/B VDD VSS sg13cmos5l_xnor2_1
X_4112_ _4147_/A _4112_/A _4112_/B VDD VSS sg13cmos5l_nand2_1
X_5092_ _5092_/Y _5023_/A _5092_/B VDD VSS sg13cmos5l_nand2b_1
X_4043_ _5898_/B _4043_/A _4044_/B VDD VSS sg13cmos5l_nor2_1
XFILLER_49_381 VDD VSS sg13cmos5l_decap_4
XFILLER_65_830 VDD VSS sg13cmos5l_decap_8
XFILLER_52_502 VDD VSS sg13cmos5l_decap_4
X_5994_ _6037_/B _6033_/B _5994_/B VDD VSS sg13cmos5l_xor2_1
XFILLER_52_524 VDD VSS sg13cmos5l_decap_8
XFILLER_80_877 VDD VSS sg13cmos5l_fill_2
X_4945_ _4948_/A _3931_/A _5269_/A _5519_/B VDD VSS sg13cmos5l_a21oi_1
XFILLER_40_708 VDD VSS sg13cmos5l_fill_2
XFILLER_52_557 VDD VSS sg13cmos5l_fill_1
XFILLER_52_579 VDD VSS sg13cmos5l_fill_1
X_7664_ _7664_/Q clkload8/A _7664_/D fanout389/X VDD VSS sg13cmos5l_dfrbpq_1
XFILLER_60_590 VDD VSS sg13cmos5l_decap_8
X_4876_ _4876_/X _4876_/A VDD VSS sg13cmos5l_buf_1
X_6615_ _6623_/A _6615_/A _6615_/B VDD VSS sg13cmos5l_nor2_2
X_7595_ _7629_/C _7595_/A _7595_/B VDD VSS sg13cmos5l_xor2_1
X_6546_ _6869_/A _6546_/A VDD VSS sg13cmos5l_inv_1
XFILLER_109_8 VDD VSS sg13cmos5l_decap_8
X_6477_ _6485_/B _6484_/A VDD VSS sg13cmos5l_inv_1
X_5428_ _5536_/A _5377_/B _5377_/A _5427_/Y VDD VSS sg13cmos5l_a21oi_1
X_5359_ _5359_/Y _5359_/A _5297_/A VDD VSS sg13cmos5l_nor2b_1
XFILLER_59_134 VDD VSS sg13cmos5l_fill_2
XFILLER_59_123 VDD VSS sg13cmos5l_decap_8
X_7029_ _7162_/C _7029_/A _7072_/B VDD VSS sg13cmos5l_nand2_1
XFILLER_59_167 VDD VSS sg13cmos5l_fill_1
XFILLER_75_649 VDD VSS sg13cmos5l_decap_8
XFILLER_74_126 VDD VSS sg13cmos5l_fill_2
XFILLER_74_115 VDD VSS sg13cmos5l_decap_8
XFILLER_70_310 VDD VSS sg13cmos5l_decap_4
XFILLER_70_332 VDD VSS sg13cmos5l_fill_2
XFILLER_99_11 VDD VSS sg13cmos5l_decap_8
XFILLER_79_933 VDD VSS sg13cmos5l_fill_1
XFILLER_78_410 VDD VSS sg13cmos5l_decap_8
XFILLER_39_808 VDD VSS sg13cmos5l_fill_1
XFILLER_78_476 VDD VSS sg13cmos5l_decap_8
XFILLER_48_92 VDD VSS sg13cmos5l_decap_8
XFILLER_74_660 VDD VSS sg13cmos5l_fill_2
XFILLER_65_159 VDD VSS sg13cmos5l_fill_2
XFILLER_80_129 VDD VSS sg13cmos5l_decap_8
XFILLER_74_682 VDD VSS sg13cmos5l_fill_1
XFILLER_73_170 VDD VSS sg13cmos5l_fill_2
XFILLER_61_310 VDD VSS sg13cmos5l_fill_2
XFILLER_61_343 VDD VSS sg13cmos5l_decap_8
XFILLER_62_888 VDD VSS sg13cmos5l_decap_8
X_4730_ _4731_/A _4730_/A VDD VSS sg13cmos5l_inv_1
X_4661_ _4721_/B _4718_/A _4661_/B VDD VSS sg13cmos5l_xnor2_1
X_7380_ _7506_/A _7373_/A _7430_/A VDD VSS sg13cmos5l_nand2b_1
X_6400_ _6410_/A _6400_/A _6401_/A VDD VSS sg13cmos5l_nor2b_2
X_6331_ _6790_/B _6331_/A _6331_/B VDD VSS sg13cmos5l_nand2_2
X_4592_ _4593_/B _4811_/A _5081_/A _4750_/A _5082_/A VDD VSS sg13cmos5l_a22oi_1
XFILLER_43_0 VDD VSS sg13cmos5l_fill_2
X_6262_ _6354_/A _6915_/A VDD VSS sg13cmos5l_inv_1
X_5213_ _5214_/B _5253_/A _5213_/B VDD VSS sg13cmos5l_xnor2_1
X_6193_ _6193_/Y _6223_/A _6193_/B VDD VSS sg13cmos5l_nor2_1
X_5144_ _5147_/A _5517_/A _5505_/A _4944_/X VDD VSS sg13cmos5l_a21oi_1
XFILLER_69_432 VDD VSS sg13cmos5l_decap_8
XFILLER_69_465 VDD VSS sg13cmos5l_decap_8
XFILLER_56_104 VDD VSS sg13cmos5l_fill_1
XFILLER_57_616 VDD VSS sg13cmos5l_fill_2
X_5075_ _5078_/A _3934_/A _5443_/A _5519_/B VDD VSS sg13cmos5l_a21oi_1
XFILLER_56_126 VDD VSS sg13cmos5l_decap_4
X_4026_ _4050_/A _4172_/B _4205_/A _4025_/Y VDD VSS sg13cmos5l_a21o_1
XFILLER_53_800 VDD VSS sg13cmos5l_decap_8
XFILLER_65_660 VDD VSS sg13cmos5l_decap_4
XFILLER_71_129 VDD VSS sg13cmos5l_fill_1
XFILLER_38_885 VDD VSS sg13cmos5l_decap_8
X_5977_ _5977_/Y _5977_/A _5977_/B VDD VSS sg13cmos5l_nand2_1
X_4928_ _4928_/Y _4928_/A _4896_/B VDD VSS sg13cmos5l_nor2b_1
X_7716_ _7716_/Q clkload4/A _7716_/D fanout382/X VDD VSS sg13cmos5l_dfrbpq_1
X_7647_ _7648_/B _7647_/A _7651_/A VDD VSS sg13cmos5l_nor2b_1
X_4859_ _4919_/S _4920_/B1 _5309_/A _4859_/B1 _4561_/X VDD VSS sg13cmos5l_a22oi_1
X_7578_ _7623_/C _7578_/A _7578_/B VDD VSS sg13cmos5l_xnor2_1
X_6529_ _6532_/B _6529_/A _7686_/Q _6589_/A VDD VSS sg13cmos5l_nand3_1
XFILLER_69_69 VDD VSS sg13cmos5l_decap_8
XFILLER_48_627 VDD VSS sg13cmos5l_fill_2
XFILLER_48_649 VDD VSS sg13cmos5l_decap_4
XFILLER_44_833 VDD VSS sg13cmos5l_decap_4
XFILLER_56_693 VDD VSS sg13cmos5l_decap_4
XFILLER_44_866 VDD VSS sg13cmos5l_decap_8
XFILLER_71_685 VDD VSS sg13cmos5l_decap_8
XFILLER_70_151 VDD VSS sg13cmos5l_fill_2
XFILLER_44_899 VDD VSS sg13cmos5l_decap_8
XFILLER_79_730 VDD VSS sg13cmos5l_fill_1
XFILLER_78_262 VDD VSS sg13cmos5l_decap_8
XFILLER_38_137 VDD VSS sg13cmos5l_decap_8
XFILLER_35_833 VDD VSS sg13cmos5l_fill_1
X_5900_ _5945_/A _5900_/A VDD VSS sg13cmos5l_buf_1
X_6880_ _6880_/Y _6880_/A _6880_/B VDD VSS sg13cmos5l_xnor2_1
X_5831_ _5928_/A _5833_/B _5833_/A VDD VSS sg13cmos5l_nor2_1
X_5762_ _5763_/B _6082_/A1 _5869_/A2 _6082_/B1 _5869_/B2 VDD VSS sg13cmos5l_a22oi_1
XFILLER_50_836 VDD VSS sg13cmos5l_fill_1
X_7501_ _7571_/A _7501_/A VDD VSS sg13cmos5l_inv_1
X_4713_ _4715_/A _4657_/B _4713_/B VDD VSS sg13cmos5l_nand2b_1
X_5693_ _5721_/A _5693_/A _5693_/B VDD VSS sg13cmos5l_xor2_1
X_4644_ _5000_/A _4644_/A VDD VSS sg13cmos5l_buf_1
X_7432_ _7434_/B _7432_/A _7582_/A _7498_/B _7574_/B VDD VSS sg13cmos5l_nand4_1
X_7363_ _7363_/Y _7363_/A _7377_/B VDD VSS sg13cmos5l_nor2_1
X_4575_ _4576_/B _5117_/B1 _4751_/A _5050_/B1 _4752_/A VDD VSS sg13cmos5l_a22oi_1
X_6314_ _6324_/A _6314_/A _6314_/B VDD VSS sg13cmos5l_nor2_2
X_7294_ _7294_/X _7294_/A _7294_/B VDD VSS sg13cmos5l_and2_1
X_6245_ _6561_/B _6245_/A VDD VSS sg13cmos5l_buf_4
X_6176_ _6177_/B _6176_/A _6175_/Y VDD VSS sg13cmos5l_nor2b_1
X_5127_ _5127_/Y _5127_/A _5087_/B VDD VSS sg13cmos5l_nor2b_1
X_5058_ _5058_/Y _5058_/A _5021_/B VDD VSS sg13cmos5l_nor2b_1
XFILLER_45_619 VDD VSS sg13cmos5l_decap_8
XFILLER_57_446 VDD VSS sg13cmos5l_decap_4
XFILLER_57_468 VDD VSS sg13cmos5l_fill_2
X_4009_ _4034_/A _4009_/A _4033_/A VDD VSS sg13cmos5l_xor2_1
XFILLER_72_438 VDD VSS sg13cmos5l_decap_8
XFILLER_72_427 VDD VSS sg13cmos5l_decap_4
XFILLER_38_660 VDD VSS sg13cmos5l_fill_1
XFILLER_111_22 VDD VSS sg13cmos5l_decap_8
XFILLER_53_652 VDD VSS sg13cmos5l_decap_8
XFILLER_41_814 VDD VSS sg13cmos5l_fill_2
XFILLER_71_26 VDD VSS sg13cmos5l_decap_8
Xrebuffer831 _7550_/A _7332_/C VDD VSS sg13cmos5l_buf_1
Xrebuffer842 _6827_/B _6404_/A VDD VSS sg13cmos5l_buf_1
XFILLER_48_413 VDD VSS sg13cmos5l_fill_1
XFILLER_36_608 VDD VSS sg13cmos5l_decap_4
XFILLER_35_129 VDD VSS sg13cmos5l_fill_1
XFILLER_48_479 VDD VSS sg13cmos5l_fill_2
XFILLER_91_8 VDD VSS sg13cmos5l_decap_8
XFILLER_71_493 VDD VSS sg13cmos5l_fill_1
XFILLER_44_696 VDD VSS sg13cmos5l_fill_1
XANTENNA_3 input34/X VDD VSS sg13cmos5l_antennanp
X_4360_ _4407_/A _4360_/A _4360_/B VDD VSS sg13cmos5l_nor2_1
X_4291_ _4292_/B _4295_/B _4295_/A VDD VSS sg13cmos5l_xor2_1
X_6030_ _6031_/B _6049_/B _6049_/A VDD VSS sg13cmos5l_xor2_1
XFILLER_79_582 VDD VSS sg13cmos5l_fill_1
XFILLER_67_722 VDD VSS sg13cmos5l_decap_8
XFILLER_82_703 VDD VSS sg13cmos5l_decap_4
XFILLER_66_254 VDD VSS sg13cmos5l_decap_8
XFILLER_66_221 VDD VSS sg13cmos5l_decap_8
X_6932_ _6932_/Y _6928_/Y _6996_/A _6931_/X VDD VSS sg13cmos5l_a21oi_2
XFILLER_54_449 VDD VSS sg13cmos5l_decap_8
XFILLER_81_268 VDD VSS sg13cmos5l_decap_8
X_6863_ _6864_/A _6863_/A1 _6869_/B _6555_/B VDD VSS sg13cmos5l_a21oi_1
X_5814_ _5876_/A _5758_/A _5813_/Y _5711_/A VDD VSS sg13cmos5l_o21ai_1
XFILLER_62_493 VDD VSS sg13cmos5l_decap_4
XFILLER_50_666 VDD VSS sg13cmos5l_fill_2
X_6794_ _6794_/Y _6794_/A _7004_/A VDD VSS sg13cmos5l_nand2_1
XFILLER_50_699 VDD VSS sg13cmos5l_decap_8
X_5745_ _5791_/S _5792_/B1 _5858_/A _5745_/B1 _6026_/B2 VDD VSS sg13cmos5l_a22oi_1
X_5676_ _5731_/A _5676_/A _5676_/B VDD VSS sg13cmos5l_nand2_1
X_4627_ _4627_/Y _4627_/A _4596_/B VDD VSS sg13cmos5l_nor2b_1
X_7415_ _7418_/A _7415_/A _7415_/B VDD VSS sg13cmos5l_nand2_2
X_7346_ _7518_/B _7353_/B _7374_/B VDD VSS sg13cmos5l_nand2_1
X_4558_ _4558_/Y _4537_/A _4558_/B VDD VSS sg13cmos5l_nand2b_1
XFILLER_106_11 VDD VSS sg13cmos5l_decap_8
X_7277_ _7277_/Y _7277_/A _7296_/A VDD VSS sg13cmos5l_nand2_1
X_4489_ _4489_/Y _4489_/A _4489_/B VDD VSS sg13cmos5l_nand2_1
X_6228_ _6228_/Y _6212_/X _6207_/Y _6227_/Y VDD VSS sg13cmos5l_o21ai_1
X_6159_ _6159_/Y _4495_/B _6136_/A _6136_/B VDD VSS sg13cmos5l_o21ai_1
XFILLER_58_744 VDD VSS sg13cmos5l_decap_8
XFILLER_66_26 VDD VSS sg13cmos5l_fill_2
XFILLER_58_799 VDD VSS sg13cmos5l_decap_8
XFILLER_72_224 VDD VSS sg13cmos5l_decap_8
XFILLER_53_460 VDD VSS sg13cmos5l_decap_4
XFILLER_41_611 VDD VSS sg13cmos5l_fill_1
XFILLER_53_482 VDD VSS sg13cmos5l_fill_2
XFILLER_80_290 VDD VSS sg13cmos5l_decap_8
XFILLER_41_644 VDD VSS sg13cmos5l_decap_4
XFILLER_41_699 VDD VSS sg13cmos5l_decap_8
XFILLER_40_187 VDD VSS sg13cmos5l_fill_2
Xrebuffer650 rebuffer650/X rebuffer651/X VDD VSS sg13cmos5l_buf_1
Xrebuffer661 rebuffer661/X rebuffer662/X VDD VSS sg13cmos5l_buf_1
Xrebuffer694 _7728_/D _7609_/A VDD VSS sg13cmos5l_buf_2
Xrebuffer672 _6722_/A1 rebuffer697/X VDD VSS sg13cmos5l_buf_1
Xrebuffer683 _6740_/A1 rebuffer722/X VDD VSS sg13cmos5l_buf_1
Xbank_A_sram.gen_ihp_256x32.u_sram_256x32_554 bank_A_sram.gen_ihp_256x32.u_sram_256x32/A_BM[6]
+ VDD VSS sg13cmos5l_tiehi
Xbank_A_sram.gen_ihp_256x32.u_sram_256x32_565 bank_A_sram.gen_ihp_256x32.u_sram_256x32_565/L_HI
+ VDD VSS sg13cmos5l_tiehi
Xbank_A_sram.gen_ihp_256x32.u_sram_256x32_576 bank_A_sram.gen_ihp_256x32.u_sram_256x32_576/L_HI
+ VDD VSS sg13cmos5l_tiehi
XFILLER_37_928 VDD VSS sg13cmos5l_decap_4
XFILLER_36_405 VDD VSS sg13cmos5l_decap_8
XFILLER_64_714 VDD VSS sg13cmos5l_decap_8
XFILLER_56_70 VDD VSS sg13cmos5l_decap_4
XFILLER_63_246 VDD VSS sg13cmos5l_decap_8
XFILLER_64_769 VDD VSS sg13cmos5l_decap_8
XFILLER_44_460 VDD VSS sg13cmos5l_fill_1
XFILLER_60_931 VDD VSS sg13cmos5l_fill_2
Xbank_B_sram.gen_ihp_256x32.u_sram_256x32_591 bank_B_sram.gen_ihp_256x32.u_sram_256x32/A_BM[9]
+ VDD VSS sg13cmos5l_tiehi
X_5530_ _5532_/A _5470_/B _5530_/B VDD VSS sg13cmos5l_nand2b_1
X_5461_ _5461_/Y _5461_/A _5461_/B VDD VSS sg13cmos5l_nor2_1
X_7200_ _7215_/A _7720_/Q VDD VSS sg13cmos5l_buf_2
X_4412_ _4475_/A _4353_/A _4353_/B _4411_/X VDD VSS sg13cmos5l_a21o_1
X_5392_ _5402_/A _5456_/A _5392_/B VDD VSS sg13cmos5l_xnor2_1
X_7131_ _7131_/Y _7130_/Y _7111_/A _7059_/Y VDD VSS sg13cmos5l_a21oi_1
X_4343_ _4343_/Y _4343_/A _4343_/B _4343_/C VDD VSS sg13cmos5l_nand3_1
Xfanout318 _6136_/B _5643_/X VDD VSS sg13cmos5l_buf_1
X_4274_ _4277_/A _3929_/X _4631_/A _4387_/A VDD VSS sg13cmos5l_a21oi_1
Xfanout307 _6937_/A _6965_/A VDD VSS sg13cmos5l_buf_1
X_7062_ _7063_/B _6940_/Y _7072_/B VDD VSS sg13cmos5l_nand2b_1
Xfanout329 _5622_/B1 _5063_/X VDD VSS sg13cmos5l_buf_1
X_6013_ _6046_/B _6012_/B _6013_/B VDD VSS sg13cmos5l_nand2b_1
XFILLER_82_511 VDD VSS sg13cmos5l_fill_2
XFILLER_36_18 VDD VSS sg13cmos5l_decap_4
XFILLER_55_725 VDD VSS sg13cmos5l_fill_2
XFILLER_82_522 VDD VSS sg13cmos5l_decap_8
XFILLER_39_287 VDD VSS sg13cmos5l_decap_8
XFILLER_82_566 VDD VSS sg13cmos5l_fill_1
X_6915_ _6915_/Y _6915_/A _6915_/B VDD VSS sg13cmos5l_nor2_1
XFILLER_82_599 VDD VSS sg13cmos5l_decap_4
X_6846_ _6846_/Y _6840_/Y _7004_/A _6845_/Y VDD VSS sg13cmos5l_a21oi_1
X_6777_ _7311_/B _6776_/X _7008_/B VDD VSS sg13cmos5l_nand2b_1
XFILLER_50_485 VDD VSS sg13cmos5l_decap_4
X_3989_ _4013_/A _4015_/B _4014_/B VDD VSS sg13cmos5l_nor2_1
X_5728_ _5729_/B _5782_/B _5782_/A VDD VSS sg13cmos5l_xnor2_1
X_5659_ _5665_/B _5659_/A VDD VSS sg13cmos5l_inv_1
X_7329_ _7336_/A _7289_/A _7326_/Y _7328_/Y VDD VSS sg13cmos5l_o21ai_1
XFILLER_77_316 VDD VSS sg13cmos5l_fill_1
XFILLER_46_725 VDD VSS sg13cmos5l_decap_8
XFILLER_45_213 VDD VSS sg13cmos5l_decap_4
XFILLER_73_555 VDD VSS sg13cmos5l_fill_1
XFILLER_45_246 VDD VSS sg13cmos5l_fill_2
XFILLER_61_739 VDD VSS sg13cmos5l_fill_2
XFILLER_41_496 VDD VSS sg13cmos5l_decap_4
XFILLER_42_94 VDD VSS sg13cmos5l_decap_8
XFILLER_69_817 VDD VSS sg13cmos5l_fill_1
XFILLER_68_338 VDD VSS sg13cmos5l_fill_2
XFILLER_68_305 VDD VSS sg13cmos5l_decap_4
Xbank_A_sram.gen_ihp_256x32.u_sram_256x32_395 bank_A_sram.gen_ihp_256x32.u_sram_256x32_395/L_LO
+ VDD VSS sg13cmos5l_tielo
XFILLER_77_861 VDD VSS sg13cmos5l_decap_8
XFILLER_67_80 VDD VSS sg13cmos5l_decap_8
XFILLER_37_703 VDD VSS sg13cmos5l_fill_1
XFILLER_36_235 VDD VSS sg13cmos5l_decap_8
X_4961_ _4962_/B _5030_/B _5030_/A VDD VSS sg13cmos5l_xor2_1
X_4892_ _4893_/B _5131_/A _5081_/A _5063_/A _5082_/A VDD VSS sg13cmos5l_a22oi_1
X_7680_ _7680_/Q _7691_/CLK _7680_/D fanout386/X VDD VSS sg13cmos5l_dfrbpq_1
X_6700_ _6703_/A _7274_/A _6700_/B VDD VSS sg13cmos5l_nor2_1
XFILLER_60_750 VDD VSS sg13cmos5l_fill_1
X_6631_ _6647_/A _6631_/A _6631_/B _6631_/C VDD VSS sg13cmos5l_nor3_2
XFILLER_60_761 VDD VSS sg13cmos5l_decap_8
XFILLER_60_794 VDD VSS sg13cmos5l_decap_8
XFILLER_73_0 VDD VSS sg13cmos5l_fill_2
X_6562_ _6571_/B _6567_/B _6567_/A _6561_/Y VDD VSS sg13cmos5l_o21ai_1
X_5513_ _5526_/A _5466_/B _5466_/A _5512_/Y VDD VSS sg13cmos5l_a21oi_1
X_6493_ _6504_/A _6491_/Y _6508_/A _6527_/A VDD VSS sg13cmos5l_o21ai_1
X_5444_ _5445_/B _5443_/X _5258_/X _5382_/X _5259_/X VDD VSS sg13cmos5l_a22oi_1
X_7114_ _7114_/Y _7114_/A _7134_/B VDD VSS sg13cmos5l_nand2_1
X_5375_ _5427_/A _5327_/B _5327_/A _5374_/X VDD VSS sg13cmos5l_a21oi_1
X_4326_ _4327_/C _4688_/A VDD VSS sg13cmos5l_inv_1
X_7045_ _7046_/A _7045_/A _7045_/B VDD VSS sg13cmos5l_nand2_1
X_4257_ _4257_/Y _6053_/B _4257_/B VDD VSS sg13cmos5l_nand2_1
XFILLER_74_319 VDD VSS sg13cmos5l_decap_8
X_4188_ _4188_/X _4188_/A _4243_/C VDD VSS sg13cmos5l_xor2_1
XFILLER_68_872 VDD VSS sg13cmos5l_decap_8
XFILLER_67_382 VDD VSS sg13cmos5l_fill_1
XFILLER_55_544 VDD VSS sg13cmos5l_decap_4
XFILLER_82_363 VDD VSS sg13cmos5l_fill_1
XFILLER_70_503 VDD VSS sg13cmos5l_fill_2
XFILLER_55_577 VDD VSS sg13cmos5l_fill_1
XFILLER_42_205 VDD VSS sg13cmos5l_decap_8
XFILLER_36_791 VDD VSS sg13cmos5l_fill_2
XFILLER_43_739 VDD VSS sg13cmos5l_decap_8
XFILLER_63_38 VDD VSS sg13cmos5l_fill_2
XFILLER_50_260 VDD VSS sg13cmos5l_fill_1
XFILLER_51_783 VDD VSS sg13cmos5l_decap_8
X_6829_ _6829_/Y _6913_/B _6829_/B VDD VSS sg13cmos5l_nor2_1
XFILLER_78_625 VDD VSS sg13cmos5l_fill_2
XFILLER_77_146 VDD VSS sg13cmos5l_decap_8
XFILLER_66_809 VDD VSS sg13cmos5l_fill_1
XFILLER_77_157 VDD VSS sg13cmos5l_fill_1
XFILLER_61_514 VDD VSS sg13cmos5l_decap_8
XFILLER_42_783 VDD VSS sg13cmos5l_decap_8
XFILLER_42_761 VDD VSS sg13cmos5l_decap_4
X_5160_ _5161_/B _5160_/A _5160_/B VDD VSS sg13cmos5l_xor2_1
X_4111_ _4112_/B _4093_/B _4111_/B VDD VSS sg13cmos5l_nand2b_1
X_5091_ _5091_/Y _5091_/A VDD VSS sg13cmos5l_inv_1
X_4042_ _4068_/A _4036_/B _4042_/B VDD VSS sg13cmos5l_nand2b_1
XFILLER_49_360 VDD VSS sg13cmos5l_decap_8
X_5993_ _5994_/B _5993_/A _5993_/B VDD VSS sg13cmos5l_xnor2_1
XFILLER_65_886 VDD VSS sg13cmos5l_decap_8
XFILLER_65_897 VDD VSS sg13cmos5l_fill_1
X_4944_ _4944_/X _4944_/A VDD VSS sg13cmos5l_buf_1
XFILLER_52_569 VDD VSS sg13cmos5l_fill_1
X_7663_ _7663_/Q clkload9/A _7663_/D fanout390/X VDD VSS sg13cmos5l_dfrbpq_1
X_4875_ _5135_/A _4875_/A VDD VSS sg13cmos5l_buf_1
X_6614_ _6615_/B _6614_/A VDD VSS sg13cmos5l_inv_1
X_7594_ _7595_/B _7594_/A _7594_/B VDD VSS sg13cmos5l_nand2_1
X_6545_ _6546_/A _6554_/B _6554_/A VDD VSS sg13cmos5l_nor2_1
X_6476_ _6484_/A _6476_/A _6476_/B VDD VSS sg13cmos5l_nand2_2
X_5427_ _5427_/Y _5427_/A _5376_/A VDD VSS sg13cmos5l_nor2b_1
X_5358_ _5362_/A _5358_/A VDD VSS sg13cmos5l_inv_1
XFILLER_59_102 VDD VSS sg13cmos5l_decap_8
X_4309_ _4318_/A _4508_/A _4309_/B VDD VSS sg13cmos5l_xnor2_1
XFILLER_114_11 VDD VSS sg13cmos5l_decap_8
XFILLER_75_628 VDD VSS sg13cmos5l_decap_8
X_5289_ _5290_/B _5351_/B _5351_/A VDD VSS sg13cmos5l_xor2_1
X_7028_ _7162_/A _7028_/A _7044_/A VDD VSS sg13cmos5l_nand2_1
XFILLER_67_190 VDD VSS sg13cmos5l_fill_1
XFILLER_55_341 VDD VSS sg13cmos5l_decap_8
XFILLER_55_352 VDD VSS sg13cmos5l_decap_8
XFILLER_71_812 VDD VSS sg13cmos5l_decap_8
XFILLER_55_363 VDD VSS sg13cmos5l_decap_4
XFILLER_55_385 VDD VSS sg13cmos5l_fill_1
XFILLER_90_25 VDD VSS sg13cmos5l_decap_4
XFILLER_78_455 VDD VSS sg13cmos5l_decap_8
XFILLER_48_60 VDD VSS sg13cmos5l_decap_8
XFILLER_17_8 VDD VSS sg13cmos5l_decap_4
XFILLER_65_127 VDD VSS sg13cmos5l_decap_4
XFILLER_65_138 VDD VSS sg13cmos5l_fill_2
XFILLER_0_23 VDD VSS sg13cmos5l_decap_4
XFILLER_80_108 VDD VSS sg13cmos5l_decap_8
XFILLER_61_322 VDD VSS sg13cmos5l_decap_8
XFILLER_9_21 VDD VSS sg13cmos5l_decap_8
XFILLER_42_580 VDD VSS sg13cmos5l_fill_1
X_4660_ _4661_/B _4660_/A _4660_/B VDD VSS sg13cmos5l_xor2_1
X_4591_ _4638_/A _4947_/B _4872_/A _4590_/Y VDD VSS sg13cmos5l_a21o_1
X_6330_ _6331_/A _6791_/B _6791_/A VDD VSS sg13cmos5l_nand2_2
X_6261_ _6356_/A _6720_/A _6972_/B VDD VSS sg13cmos5l_nor2_2
X_5212_ _5213_/B _5212_/A _5212_/B VDD VSS sg13cmos5l_xor2_1
X_6192_ _6192_/Y _6192_/A VDD VSS sg13cmos5l_inv_1
X_5143_ _5505_/A _5143_/A VDD VSS sg13cmos5l_buf_1
XFILLER_28_19 VDD VSS sg13cmos5l_fill_1
X_5074_ _5443_/A _5074_/A VDD VSS sg13cmos5l_buf_1
X_4025_ _4025_/Y _4025_/A _4025_/B VDD VSS sg13cmos5l_nor2_1
XFILLER_65_672 VDD VSS sg13cmos5l_decap_8
XFILLER_65_683 VDD VSS sg13cmos5l_fill_2
X_5976_ _6037_/A _5947_/B _5947_/A _5975_/Y VDD VSS sg13cmos5l_a21oi_1
X_7715_ _7715_/Q clkload4/A _7715_/D fanout382/X VDD VSS sg13cmos5l_dfrbpq_1
X_4927_ _5025_/A _4927_/A _4927_/B VDD VSS sg13cmos5l_xor2_1
X_7646_ _7647_/A _7646_/A1 _7641_/B _7123_/B VDD VSS sg13cmos5l_a21oi_1
X_4858_ _4866_/A _4802_/B _4854_/A _4858_/S VDD VSS sg13cmos5l_mux2_1
XFILLER_109_22 VDD VSS sg13cmos5l_decap_8
X_4789_ _7678_/D _4847_/B _4847_/A VDD VSS sg13cmos5l_xor2_1
X_7577_ _7578_/B _7503_/B _7503_/A _7414_/B VDD VSS sg13cmos5l_a21oi_1
X_6528_ _6530_/A _6529_/A _6589_/A _7686_/Q VDD VSS sg13cmos5l_a21oi_1
XFILLER_69_26 VDD VSS sg13cmos5l_decap_8
XFILLER_69_15 VDD VSS sg13cmos5l_fill_1
X_6459_ _6459_/X _6461_/C VDD VSS sg13cmos5l_buf_4
XFILLER_79_219 VDD VSS sg13cmos5l_decap_8
XFILLER_75_414 VDD VSS sg13cmos5l_decap_8
XFILLER_75_469 VDD VSS sg13cmos5l_decap_8
XFILLER_44_845 VDD VSS sg13cmos5l_fill_2
XFILLER_50_72 VDD VSS sg13cmos5l_decap_4
XFILLER_78_241 VDD VSS sg13cmos5l_decap_8
XFILLER_79_797 VDD VSS sg13cmos5l_fill_2
XFILLER_66_436 VDD VSS sg13cmos5l_fill_1
XFILLER_39_639 VDD VSS sg13cmos5l_decap_8
XFILLER_38_116 VDD VSS sg13cmos5l_decap_8
XFILLER_47_650 VDD VSS sg13cmos5l_fill_1
XFILLER_35_867 VDD VSS sg13cmos5l_decap_4
XFILLER_35_856 VDD VSS sg13cmos5l_decap_8
X_5830_ _5833_/A _5830_/A VDD VSS sg13cmos5l_inv_1
X_5761_ _5767_/A _5982_/A _5761_/B VDD VSS sg13cmos5l_xnor2_1
XFILLER_50_848 VDD VSS sg13cmos5l_fill_2
X_4712_ _4716_/A _4778_/B _4712_/B VDD VSS sg13cmos5l_xnor2_1
X_7500_ _7572_/A _7500_/A VDD VSS sg13cmos5l_inv_1
X_7431_ _7574_/B _7431_/A _7464_/B VDD VSS sg13cmos5l_nand2_1
X_5692_ _5693_/B _5692_/A _5739_/A VDD VSS sg13cmos5l_xnor2_1
X_4643_ _4653_/A _4761_/A _4643_/B VDD VSS sg13cmos5l_xnor2_1
X_7362_ _7363_/A _7404_/A _7362_/B VDD VSS sg13cmos5l_nor2_1
X_4574_ _4574_/X _4574_/A VDD VSS sg13cmos5l_buf_1
X_7293_ _7304_/B _7556_/A _7554_/B VDD VSS sg13cmos5l_and2_1
X_6313_ _6324_/B _6343_/A _6565_/B _6611_/C VDD VSS sg13cmos5l_nand3_1
X_6244_ _6245_/A _6244_/A _6254_/A _6516_/A _6697_/A VDD VSS sg13cmos5l_nand4_1
XFILLER_39_29 VDD VSS sg13cmos5l_decap_8
X_6175_ _6175_/Y _6175_/A _6175_/B _6175_/C VDD VSS sg13cmos5l_nand3_1
X_5126_ _5217_/B _5126_/A _5126_/B VDD VSS sg13cmos5l_xor2_1
XFILLER_73_918 VDD VSS sg13cmos5l_decap_8
X_5057_ _5157_/A _5057_/A _5057_/B VDD VSS sg13cmos5l_xor2_1
XFILLER_55_17 VDD VSS sg13cmos5l_fill_1
X_4008_ _4009_/A _4027_/A _4008_/B VDD VSS sg13cmos5l_xnor2_1
XFILLER_72_406 VDD VSS sg13cmos5l_fill_1
XFILLER_38_683 VDD VSS sg13cmos5l_fill_1
XFILLER_38_672 VDD VSS sg13cmos5l_fill_1
XFILLER_55_39 VDD VSS sg13cmos5l_fill_2
XFILLER_37_193 VDD VSS sg13cmos5l_decap_8
XFILLER_80_483 VDD VSS sg13cmos5l_decap_8
XFILLER_41_837 VDD VSS sg13cmos5l_fill_1
X_5959_ _5998_/A _5999_/B _5999_/A VDD VSS sg13cmos5l_xor2_1
XFILLER_52_174 VDD VSS sg13cmos5l_fill_2
Xrebuffer832 _7642_/A _7097_/A VDD VSS sg13cmos5l_buf_1
X_7629_ _7630_/A _7629_/A _7629_/B _7629_/C _7629_/D VDD VSS sg13cmos5l_nand4_1
Xrebuffer843 _6848_/B _6453_/A VDD VSS sg13cmos5l_buf_1
XFILLER_112_4 VDD VSS sg13cmos5l_decap_8
XFILLER_76_756 VDD VSS sg13cmos5l_decap_4
XFILLER_75_266 VDD VSS sg13cmos5l_fill_1
XFILLER_63_428 VDD VSS sg13cmos5l_fill_2
XFILLER_63_439 VDD VSS sg13cmos5l_fill_1
XFILLER_71_461 VDD VSS sg13cmos5l_decap_8
XFILLER_45_50 VDD VSS sg13cmos5l_fill_1
XFILLER_44_686 VDD VSS sg13cmos5l_decap_4
XFILLER_43_196 VDD VSS sg13cmos5l_fill_1
XFILLER_84_8 VDD VSS sg13cmos5l_decap_8
Xclkbuf_4_12_0_clk_i_regs _7719_/CLK clkbuf_0_clk_i_regs/X VDD VSS sg13cmos5l_buf_8
XFILLER_6_22 VDD VSS sg13cmos5l_decap_8
XANTENNA_4 _7718_/Q VDD VSS sg13cmos5l_antennanp
X_4290_ _4295_/A _4296_/B _4296_/A VDD VSS sg13cmos5l_xor2_1
XFILLER_79_561 VDD VSS sg13cmos5l_fill_1
XFILLER_39_425 VDD VSS sg13cmos5l_decap_4
XFILLER_67_778 VDD VSS sg13cmos5l_fill_1
XFILLER_67_767 VDD VSS sg13cmos5l_decap_8
XFILLER_82_726 VDD VSS sg13cmos5l_decap_4
XFILLER_55_929 VDD VSS sg13cmos5l_decap_4
XFILLER_81_247 VDD VSS sg13cmos5l_decap_8
X_6931_ _6931_/X _6931_/A _7034_/B VDD VSS sg13cmos5l_and2_1
X_6862_ _6862_/X _6862_/A _6862_/B VDD VSS sg13cmos5l_xor2_1
X_5813_ _5813_/Y _5813_/A VDD VSS sg13cmos5l_inv_1
XFILLER_50_612 VDD VSS sg13cmos5l_decap_4
X_6793_ _6794_/A _6968_/A _6896_/B _6792_/Y VDD VSS sg13cmos5l_a21oi_1
X_5744_ _5752_/A _5689_/B _5415_/A _5744_/S VDD VSS sg13cmos5l_mux2_1
X_5675_ _7692_/D _5675_/A _5736_/A VDD VSS sg13cmos5l_nor2b_2
X_4626_ _4713_/B _4626_/A _4626_/B VDD VSS sg13cmos5l_xor2_1
X_7414_ _7415_/B _7414_/A _7414_/B _7414_/C VDD VSS sg13cmos5l_nor3_1
X_7345_ _7353_/B _7349_/A _7137_/Y _7344_/Y VDD VSS sg13cmos5l_o21ai_1
X_4557_ _4557_/Y _4557_/A VDD VSS sg13cmos5l_inv_1
X_7276_ _7276_/X _7192_/Y _7178_/X _7276_/S VDD VSS sg13cmos5l_mux2_1
X_4488_ _5044_/A _4854_/A VDD VSS sg13cmos5l_inv_1
XFILLER_77_509 VDD VSS sg13cmos5l_fill_1
X_6227_ _6227_/Y _6227_/A _6227_/B VDD VSS sg13cmos5l_nand2_1
XFILLER_58_701 VDD VSS sg13cmos5l_fill_1
X_6158_ _6178_/A _6149_/Y _6168_/A _6150_/A VDD VSS sg13cmos5l_a21oi_1
X_5109_ _5111_/A _5109_/A _5109_/B VDD VSS sg13cmos5l_nand2_1
XFILLER_46_907 VDD VSS sg13cmos5l_fill_1
XFILLER_58_767 VDD VSS sg13cmos5l_decap_4
XFILLER_45_417 VDD VSS sg13cmos5l_decap_8
X_6089_ _6090_/B _6089_/A _6123_/B VDD VSS sg13cmos5l_nand2_1
XFILLER_57_255 VDD VSS sg13cmos5l_fill_1
XFILLER_73_748 VDD VSS sg13cmos5l_fill_1
XFILLER_72_214 VDD VSS sg13cmos5l_fill_2
XFILLER_57_288 VDD VSS sg13cmos5l_fill_2
XFILLER_82_37 VDD VSS sg13cmos5l_decap_4
XFILLER_82_59 VDD VSS sg13cmos5l_decap_8
XFILLER_40_111 VDD VSS sg13cmos5l_decap_8
Xrebuffer640 rebuffer640/X rebuffer834/X VDD VSS sg13cmos5l_buf_1
Xrebuffer651 rebuffer651/X rebuffer652/X VDD VSS sg13cmos5l_buf_1
Xrebuffer673 rebuffer673/X rebuffer674/X VDD VSS sg13cmos5l_buf_1
Xrebuffer662 rebuffer662/X rebuffer663/X VDD VSS sg13cmos5l_buf_1
Xrebuffer684 rebuffer684/X rebuffer685/X VDD VSS sg13cmos5l_buf_1
Xrebuffer695 _7596_/A _7626_/A VDD VSS sg13cmos5l_buf_1
XFILLER_48_200 VDD VSS sg13cmos5l_decap_8
Xbank_A_sram.gen_ihp_256x32.u_sram_256x32_555 bank_A_sram.gen_ihp_256x32.u_sram_256x32/A_BM[7]
+ VDD VSS sg13cmos5l_tiehi
Xbank_A_sram.gen_ihp_256x32.u_sram_256x32_566 bank_A_sram.gen_ihp_256x32.u_sram_256x32_566/L_HI
+ VDD VSS sg13cmos5l_tiehi
Xbank_A_sram.gen_ihp_256x32.u_sram_256x32_577 bank_A_sram.gen_ihp_256x32.u_sram_256x32_577/L_HI
+ VDD VSS sg13cmos5l_tiehi
XFILLER_37_907 VDD VSS sg13cmos5l_decap_8
XFILLER_48_211 VDD VSS sg13cmos5l_fill_1
XFILLER_49_778 VDD VSS sg13cmos5l_fill_1
XFILLER_63_203 VDD VSS sg13cmos5l_fill_2
XFILLER_44_483 VDD VSS sg13cmos5l_decap_8
Xbank_B_sram.gen_ihp_256x32.u_sram_256x32_592 bank_B_sram.gen_ihp_256x32.u_sram_256x32_592/L_HI
+ VDD VSS sg13cmos5l_tiehi
XFILLER_72_81 VDD VSS sg13cmos5l_fill_2
X_5460_ _5461_/B _5460_/A _5460_/B _5460_/C VDD VSS sg13cmos5l_nor3_1
XFILLER_75_4 VDD VSS sg13cmos5l_fill_2
X_4411_ _4411_/X _4411_/A _4411_/B VDD VSS sg13cmos5l_and2_1
X_5391_ _5392_/B _5505_/A _5199_/X _5443_/A _5200_/X VDD VSS sg13cmos5l_a22oi_1
X_7130_ _7130_/Y _7126_/Y _7153_/A _7129_/Y VDD VSS sg13cmos5l_a21oi_2
X_4342_ _4355_/A _4343_/A _4343_/B _4343_/C VDD VSS sg13cmos5l_a21oi_1
X_4273_ _4631_/A _4273_/A VDD VSS sg13cmos5l_buf_1
Xfanout319 _6058_/B1 _5633_/X VDD VSS sg13cmos5l_buf_1
Xfanout308 _6939_/A _6974_/B VDD VSS sg13cmos5l_buf_1
X_7061_ _7063_/A _7061_/A _7085_/B VDD VSS sg13cmos5l_nand2_1
XFILLER_59_509 VDD VSS sg13cmos5l_decap_4
X_6012_ _6018_/C _6013_/B _6012_/B VDD VSS sg13cmos5l_nand2b_1
.ends
